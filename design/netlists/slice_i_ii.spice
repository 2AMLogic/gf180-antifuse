* expanding   symbol:  slice_i_ii.sym # of pins=16
** sym_path: design/array/slice_i_ii.sym
** sch_path: design/array/slice_i_ii.sch
.subckt slice_i_ii RSEL_0 RSEL_1 RSEL_2 RSEL_3 CSEL_9 CSEL_10 CSEL_11 CSEL_12 BLG_I PLG_I BLG_II PLG_II VDDH_I VDDH_II VDDL VSS
*.ipin RSEL_0
*.ipin RSEL_1
*.ipin RSEL_2
*.ipin RSEL_3
*.ipin CSEL_9
*.ipin CSEL_10
*.ipin CSEL_11
*.ipin CSEL_12
*.iopin BLG_I
*.iopin PLG_I
*.iopin BLG_II
*.iopin PLG_II
*.ipin VDDH_I
*.ipin VDDH_II
*.ipin VDDL
*.ipin VSS
Xc_0_9 BL_9 WL_0_I PL_0_I VSS cell_candidate1 wcap=2e-6 lcap=1e-6 wacc=0.30u lacc=0.70u m=1
Xc_0_10 BL_10 WL_0_I PL_0_I VSS cell_candidate1 wcap=1e-6 lcap=1e-6 wacc=0.6u lacc=0.70u m=1
Xc_0_11 BL_11 WL_0_II PL_0_II VSS cell_candidate2 wcap=1e-6 lcap=1e-6 wacc=25u lacc=0.60u m=1
Xc_0_12 BL_12 WL_0_II PL_0_II VSS cell_candidate2 wcap=2e-6 lcap=1e-6 wacc=25u lacc=0.60u m=1
Xc_1_9 BL_9 WL_1_I PL_1_I VSS cell_candidate1 wcap=1e-6 lcap=1e-6 wacc=0.30u lacc=0.70u m=1
Xc_1_10 BL_10 WL_1_I PL_1_I VSS cell_candidate1 wcap=2e-6 lcap=1e-6 wacc=0.6u lacc=0.70u m=1
Xc_1_11 BL_11 WL_1_II PL_1_II VSS cell_candidate2 wcap=2e-6 lcap=1e-6 wacc=25u lacc=0.60u m=1
Xc_1_12 BL_12 WL_1_II PL_1_II VSS cell_candidate2 wcap=1e-6 lcap=1e-6 wacc=25u lacc=0.60u m=1
Xc_2_9 BL_9 WL_2_I PL_2_I VSS cell_candidate1 wcap=2e-6 lcap=1e-6 wacc=0.6u lacc=0.70u m=1
Xc_2_10 BL_10 WL_2_I PL_2_I VSS cell_candidate1 wcap=1e-6 lcap=1e-6 wacc=0.30u lacc=0.70u m=1
Xc_2_11 BL_11 WL_2_II PL_2_II VSS cell_candidate2 wcap=1e-6 lcap=1e-6 wacc=50u lacc=0.60u m=1
Xc_2_12 BL_12 WL_2_II PL_2_II VSS cell_candidate2 wcap=2e-6 lcap=1e-6 wacc=50u lacc=0.60u m=1
Xc_3_9 BL_9 WL_3_I PL_3_I VSS cell_candidate1 wcap=1e-6 lcap=1e-6 wacc=0.6u lacc=0.70u m=1
Xc_3_10 BL_10 WL_3_I PL_3_I VSS cell_candidate1 wcap=2e-6 lcap=1e-6 wacc=0.30u lacc=0.70u m=1
Xc_3_11 BL_11 WL_3_II PL_3_II VSS cell_candidate2 wcap=2e-6 lcap=1e-6 wacc=50u lacc=0.60u m=1
Xc_3_12 BL_12 WL_3_II PL_3_II VSS cell_candidate2 wcap=1e-6 lcap=1e-6 wacc=50u lacc=0.60u m=1
XLC_9 CSEL_9 VDDL VSS CG_9 CGB_9 VDDH_I ls_hv06 wpdn=10u lpdn=0.70u wpup=1u lpup=0.55u
XPC_9 BLG_I CG_9 BL_9 VSS pg_n06 wpg=20u lpg=0.70u
XLC_10 CSEL_10 VDDL VSS CG_10 CGB_10 VDDH_I ls_hv06 wpdn=10u lpdn=0.70u wpup=1u lpup=0.55u
XPC_10 BLG_I CG_10 BL_10 VSS pg_n06 wpg=20u lpg=0.70u
XLC_11 CSEL_11 VDDL VSS CG_11 CGB_11 VDDH_II ls_hv10 wpdn=20u lpdn=0.60u wpup=5u lpup=0.60u
XPC_11 BLG_II CG_11 BL_11 VSS pg_n10 wpg=25u lpg=0.60u
XLC_12 CSEL_12 VDDL VSS CG_12 CGB_12 VDDH_II ls_hv10 wpdn=20u lpdn=0.60u wpup=5u lpup=0.60u
XPC_12 BLG_II CG_12 BL_12 VSS pg_n10 wpg=25u lpg=0.60u
XLR_0_I RSEL_0 VDDL VSS WL_0_I RGB_0_I VDDH_I ls_hv06 wpdn=10u lpdn=0.70u wpup=1u lpup=0.55u
XPR_0_I PL_0_I WL_0_I PLG_I VSS pg_n06 wpg=20u lpg=0.70u
XLR_1_I RSEL_1 VDDL VSS WL_1_I RGB_1_I VDDH_I ls_hv06 wpdn=10u lpdn=0.70u wpup=1u lpup=0.55u
XPR_1_I PL_1_I WL_1_I PLG_I VSS pg_n06 wpg=20u lpg=0.70u
XLR_2_I RSEL_2 VDDL VSS WL_2_I RGB_2_I VDDH_I ls_hv06 wpdn=10u lpdn=0.70u wpup=1u lpup=0.55u
XPR_2_I PL_2_I WL_2_I PLG_I VSS pg_n06 wpg=20u lpg=0.70u
XLR_3_I RSEL_3 VDDL VSS WL_3_I RGB_3_I VDDH_I ls_hv06 wpdn=10u lpdn=0.70u wpup=1u lpup=0.55u
XPR_3_I PL_3_I WL_3_I PLG_I VSS pg_n06 wpg=20u lpg=0.70u
XLR_0_II RSEL_0 VDDL VSS WL_0_II RGB_0_II VDDH_II ls_hv10 wpdn=20u lpdn=0.60u wpup=5u lpup=0.60u
XPR_0_II PL_0_II WL_0_II PLG_II VSS pg_n10 wpg=25u lpg=0.60u
XLR_1_II RSEL_1 VDDL VSS WL_1_II RGB_1_II VDDH_II ls_hv10 wpdn=20u lpdn=0.60u wpup=5u lpup=0.60u
XPR_1_II PL_1_II WL_1_II PLG_II VSS pg_n10 wpg=25u lpg=0.60u
XLR_2_II RSEL_2 VDDL VSS WL_2_II RGB_2_II VDDH_II ls_hv10 wpdn=20u lpdn=0.60u wpup=5u lpup=0.60u
XPR_2_II PL_2_II WL_2_II PLG_II VSS pg_n10 wpg=25u lpg=0.60u
XLR_3_II RSEL_3 VDDL VSS WL_3_II RGB_3_II VDDH_II ls_hv10 wpdn=20u lpdn=0.60u wpup=5u lpup=0.60u
XPR_3_II PL_3_II WL_3_II PLG_II VSS pg_n10 wpg=25u lpg=0.60u
.ends
