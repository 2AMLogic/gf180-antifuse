* expanding   symbol:  band_iii.sym # of pins=19
** sym_path: design/array/band_iii.sym
** sch_path: design/array/band_iii.sch
.subckt band_iii RSEL_0 RSEL_1 RSEL_2 RSEL_3 CSEL_22 CSEL_23 CSEL_24 CSEL_25 CSEL_26 CSEL_27 CSEL_28 CSEL_29 CSEL_30 CSEL_31 BLG_III PLG_III VDDH_III VDDL VSS
*.ipin RSEL_0
*.ipin RSEL_1
*.ipin RSEL_2
*.ipin RSEL_3
*.ipin CSEL_22
*.ipin CSEL_23
*.ipin CSEL_24
*.ipin CSEL_25
*.ipin CSEL_26
*.ipin CSEL_27
*.ipin CSEL_28
*.ipin CSEL_29
*.ipin CSEL_30
*.ipin CSEL_31
*.iopin BLG_III
*.iopin PLG_III
*.ipin VDDH_III
*.ipin VDDL
*.ipin VSS
Xc_0_22 BL_22 WL_0_III PL_0_III VDDH_III cell_candidate3 wcap=1e-6 lcap=1e-6 wacc=0.30u lacc=0.55u m=1
Xc_0_23 BL_23 WL_0_III PL_0_III VDDH_III cell_candidate3 wcap=2e-6 lcap=1e-6 wacc=0.30u lacc=0.55u m=1
Xc_0_24 BL_24 WL_0_III PL_0_III VDDH_III cell_candidate3 wcap=1e-6 lcap=1e-6 wacc=0.6u lacc=0.55u m=1
Xc_0_25 BL_25 WL_0_III PL_0_III VDDH_III cell_candidate3 wcap=2e-6 lcap=1e-6 wacc=0.6u lacc=0.55u m=1
Xc_0_26 BL_26 WL_0_III PL_0_III VDDH_III cell_candidate3 wcap=1e-6 lcap=1e-6 wacc=0.30u lacc=0.55u m=1
Xc_0_27 BL_27 WL_0_III PL_0_III VDDH_III cell_candidate3 wcap=2e-6 lcap=1e-6 wacc=0.30u lacc=0.55u m=1
Xc_0_28 BL_28 WL_0_III PL_0_III VDDH_III cell_candidate3 wcap=1e-6 lcap=1e-6 wacc=0.6u lacc=0.55u m=1
Xc_0_29 BL_29 WL_0_III PL_0_III VDDH_III cell_candidate3 wcap=2e-6 lcap=1e-6 wacc=0.6u lacc=0.55u m=1
Xc_0_30 BL_30 WL_0_III PL_0_III VDDH_III cell_candidate3 wcap=1e-6 lcap=1e-6 wacc=0.30u lacc=0.55u m=1
Xc_0_31 BL_31 WL_0_III PL_0_III VDDH_III cell_candidate3 wcap=2e-6 lcap=1e-6 wacc=0.30u lacc=0.55u m=1
Xc_1_22 BL_22 WL_1_III PL_1_III VDDH_III cell_candidate3 wcap=2e-6 lcap=1e-6 wacc=0.30u lacc=0.55u m=1
Xc_1_23 BL_23 WL_1_III PL_1_III VDDH_III cell_candidate3 wcap=1e-6 lcap=1e-6 wacc=0.30u lacc=0.55u m=1
Xc_1_24 BL_24 WL_1_III PL_1_III VDDH_III cell_candidate3 wcap=2e-6 lcap=1e-6 wacc=0.6u lacc=0.55u m=1
Xc_1_25 BL_25 WL_1_III PL_1_III VDDH_III cell_candidate3 wcap=1e-6 lcap=1e-6 wacc=0.6u lacc=0.55u m=1
Xc_1_26 BL_26 WL_1_III PL_1_III VDDH_III cell_candidate3 wcap=2e-6 lcap=1e-6 wacc=0.30u lacc=0.55u m=1
Xc_1_27 BL_27 WL_1_III PL_1_III VDDH_III cell_candidate3 wcap=1e-6 lcap=1e-6 wacc=0.30u lacc=0.55u m=1
Xc_1_28 BL_28 WL_1_III PL_1_III VDDH_III cell_candidate3 wcap=2e-6 lcap=1e-6 wacc=0.6u lacc=0.55u m=1
Xc_1_29 BL_29 WL_1_III PL_1_III VDDH_III cell_candidate3 wcap=1e-6 lcap=1e-6 wacc=0.6u lacc=0.55u m=1
Xc_1_30 BL_30 WL_1_III PL_1_III VDDH_III cell_candidate3 wcap=2e-6 lcap=1e-6 wacc=0.30u lacc=0.55u m=1
Xc_1_31 BL_31 WL_1_III PL_1_III VDDH_III cell_candidate3 wcap=1e-6 lcap=1e-6 wacc=0.30u lacc=0.55u m=1
Xc_2_22 BL_22 WL_2_III PL_2_III VDDH_III cell_candidate3 wcap=1e-6 lcap=1e-6 wacc=0.6u lacc=0.55u m=1
Xc_2_23 BL_23 WL_2_III PL_2_III VDDH_III cell_candidate3 wcap=2e-6 lcap=1e-6 wacc=0.6u lacc=0.55u m=1
Xc_2_24 BL_24 WL_2_III PL_2_III VDDH_III cell_candidate3 wcap=1e-6 lcap=1e-6 wacc=0.30u lacc=0.55u m=1
Xc_2_25 BL_25 WL_2_III PL_2_III VDDH_III cell_candidate3 wcap=2e-6 lcap=1e-6 wacc=0.30u lacc=0.55u m=1
Xc_2_26 BL_26 WL_2_III PL_2_III VDDH_III cell_candidate3 wcap=1e-6 lcap=1e-6 wacc=0.6u lacc=0.55u m=1
Xc_2_27 BL_27 WL_2_III PL_2_III VDDH_III cell_candidate3 wcap=2e-6 lcap=1e-6 wacc=0.6u lacc=0.55u m=1
Xc_2_28 BL_28 WL_2_III PL_2_III VDDH_III cell_candidate3 wcap=1e-6 lcap=1e-6 wacc=0.30u lacc=0.55u m=1
Xc_2_29 BL_29 WL_2_III PL_2_III VDDH_III cell_candidate3 wcap=2e-6 lcap=1e-6 wacc=0.30u lacc=0.55u m=1
Xc_2_30 BL_30 WL_2_III PL_2_III VDDH_III cell_candidate3 wcap=1e-6 lcap=1e-6 wacc=0.6u lacc=0.55u m=1
Xc_2_31 BL_31 WL_2_III PL_2_III VDDH_III cell_candidate3 wcap=2e-6 lcap=1e-6 wacc=0.6u lacc=0.55u m=1
Xc_3_22 BL_22 WL_3_III PL_3_III VDDH_III cell_candidate3 wcap=2e-6 lcap=1e-6 wacc=0.6u lacc=0.55u m=1
Xc_3_23 BL_23 WL_3_III PL_3_III VDDH_III cell_candidate3 wcap=1e-6 lcap=1e-6 wacc=0.6u lacc=0.55u m=1
Xc_3_24 BL_24 WL_3_III PL_3_III VDDH_III cell_candidate3 wcap=2e-6 lcap=1e-6 wacc=0.30u lacc=0.55u m=1
Xc_3_25 BL_25 WL_3_III PL_3_III VDDH_III cell_candidate3 wcap=1e-6 lcap=1e-6 wacc=0.30u lacc=0.55u m=1
Xc_3_26 BL_26 WL_3_III PL_3_III VDDH_III cell_candidate3 wcap=2e-6 lcap=1e-6 wacc=0.6u lacc=0.55u m=1
Xc_3_27 BL_27 WL_3_III PL_3_III VDDH_III cell_candidate3 wcap=1e-6 lcap=1e-6 wacc=0.6u lacc=0.55u m=1
Xc_3_28 BL_28 WL_3_III PL_3_III VDDH_III cell_candidate3 wcap=2e-6 lcap=1e-6 wacc=0.30u lacc=0.55u m=1
Xc_3_29 BL_29 WL_3_III PL_3_III VDDH_III cell_candidate3 wcap=1e-6 lcap=1e-6 wacc=0.30u lacc=0.55u m=1
Xc_3_30 BL_30 WL_3_III PL_3_III VDDH_III cell_candidate3 wcap=2e-6 lcap=1e-6 wacc=0.6u lacc=0.55u m=1
Xc_3_31 BL_31 WL_3_III PL_3_III VDDH_III cell_candidate3 wcap=1e-6 lcap=1e-6 wacc=0.6u lacc=0.55u m=1
XLC_22 CSEL_22 VDDL VSS CG_22 CGB_22 VDDH_III ls_hv06 wpdn=10u lpdn=0.70u wpup=1u lpup=0.55u
XPC_22 BLG_III CG_22 BL_22 VSS pg_n06 wpg=20u lpg=0.70u
XLC_23 CSEL_23 VDDL VSS CG_23 CGB_23 VDDH_III ls_hv06 wpdn=10u lpdn=0.70u wpup=1u lpup=0.55u
XPC_23 BLG_III CG_23 BL_23 VSS pg_n06 wpg=20u lpg=0.70u
XLC_24 CSEL_24 VDDL VSS CG_24 CGB_24 VDDH_III ls_hv06 wpdn=10u lpdn=0.70u wpup=1u lpup=0.55u
XPC_24 BLG_III CG_24 BL_24 VSS pg_n06 wpg=20u lpg=0.70u
XLC_25 CSEL_25 VDDL VSS CG_25 CGB_25 VDDH_III ls_hv06 wpdn=10u lpdn=0.70u wpup=1u lpup=0.55u
XPC_25 BLG_III CG_25 BL_25 VSS pg_n06 wpg=20u lpg=0.70u
XLC_26 CSEL_26 VDDL VSS CG_26 CGB_26 VDDH_III ls_hv06 wpdn=10u lpdn=0.70u wpup=1u lpup=0.55u
XPC_26 BLG_III CG_26 BL_26 VSS pg_n06 wpg=20u lpg=0.70u
XLC_27 CSEL_27 VDDL VSS CG_27 CGB_27 VDDH_III ls_hv06 wpdn=10u lpdn=0.70u wpup=1u lpup=0.55u
XPC_27 BLG_III CG_27 BL_27 VSS pg_n06 wpg=20u lpg=0.70u
XLC_28 CSEL_28 VDDL VSS CG_28 CGB_28 VDDH_III ls_hv06 wpdn=10u lpdn=0.70u wpup=1u lpup=0.55u
XPC_28 BLG_III CG_28 BL_28 VSS pg_n06 wpg=20u lpg=0.70u
XLC_29 CSEL_29 VDDL VSS CG_29 CGB_29 VDDH_III ls_hv06 wpdn=10u lpdn=0.70u wpup=1u lpup=0.55u
XPC_29 BLG_III CG_29 BL_29 VSS pg_n06 wpg=20u lpg=0.70u
XLC_30 CSEL_30 VDDL VSS CG_30 CGB_30 VDDH_III ls_hv06 wpdn=10u lpdn=0.70u wpup=1u lpup=0.55u
XPC_30 BLG_III CG_30 BL_30 VSS pg_n06 wpg=20u lpg=0.70u
XLC_31 CSEL_31 VDDL VSS CG_31 CGB_31 VDDH_III ls_hv06 wpdn=10u lpdn=0.70u wpup=1u lpup=0.55u
XPC_31 BLG_III CG_31 BL_31 VSS pg_n06 wpg=20u lpg=0.70u
XLR_0_III RSEL_0 VDDL VSS RG_0_III WL_0_III VDDH_III ls_hv06 wpdn=10u lpdn=0.70u wpup=1u lpup=0.55u
XPR_0_III PL_0_III RG_0_III PLG_III VSS pg_n06 wpg=20u lpg=0.70u
XLR_1_III RSEL_1 VDDL VSS RG_1_III WL_1_III VDDH_III ls_hv06 wpdn=10u lpdn=0.70u wpup=1u lpup=0.55u
XPR_1_III PL_1_III RG_1_III PLG_III VSS pg_n06 wpg=20u lpg=0.70u
XLR_2_III RSEL_2 VDDL VSS RG_2_III WL_2_III VDDH_III ls_hv06 wpdn=10u lpdn=0.70u wpup=1u lpup=0.55u
XPR_2_III PL_2_III RG_2_III PLG_III VSS pg_n06 wpg=20u lpg=0.70u
XLR_3_III RSEL_3 VDDL VSS RG_3_III WL_3_III VDDH_III ls_hv06 wpdn=10u lpdn=0.70u wpup=1u lpup=0.55u
XPR_3_III PL_3_III RG_3_III PLG_III VSS pg_n06 wpg=20u lpg=0.70u
.ends
