* expanding   symbol:  ls_hv06.sym # of pins=6
** sym_path: design/mux/ls_hv06.sym
** sch_path: design/mux/ls_hv06.sch
.subckt ls_hv06 IN VDDL VSS OUT OUTB VDDH  wpdn=10u lpdn=0.70u wpup=1u lpup=0.55u
*.ipin IN
*.ipin VDDL
*.ipin VSS
*.opin OUT
*.opin OUTB
*.ipin VDDH
XM1 INB IN VSS VSS nfet_03v3 L=0.28u W=2u nf=1 ad='int((nf+1)/2) * 2u/nf * 0.18u' as='int((nf+2)/2) * 2u/nf * 0.18u' pd='2*int((nf+1)/2) * (2u/nf + 0.18u)'
+ ps='2*int((nf+2)/2) * (2u/nf + 0.18u)' nrd='0.18u / 2u' nrs='0.18u / 2u' sa=0 sb=0 sd=0 m=1
XM2 INB IN VDDL VDDL pfet_03v3 L=0.28u W=4u nf=1 ad='int((nf+1)/2) * 4u/nf * 0.18u' as='int((nf+2)/2) * 4u/nf * 0.18u' pd='2*int((nf+1)/2) * (4u/nf + 0.18u)'
+ ps='2*int((nf+2)/2) * (4u/nf + 0.18u)' nrd='0.18u / 4u' nrs='0.18u / 4u' sa=0 sb=0 sd=0 m=1
XM3 OUTB IN VSS VSS nfet_06v0 L=lpdn W=wpdn nf=1 ad='int((nf+1)/2) * wpdn/nf * 0.18u' as='int((nf+2)/2) * wpdn/nf * 0.18u' pd='2*int((nf+1)/2) * (wpdn/nf + 0.18u)'
+ ps='2*int((nf+2)/2) * (wpdn/nf + 0.18u)' nrd='0.18u / wpdn' nrs='0.18u / wpdn' sa=0 sb=0 sd=0 m=1
XM4 OUT INB VSS VSS nfet_06v0 L=lpdn W=wpdn nf=1 ad='int((nf+1)/2) * wpdn/nf * 0.18u' as='int((nf+2)/2) * wpdn/nf * 0.18u' pd='2*int((nf+1)/2) * (wpdn/nf + 0.18u)'
+ ps='2*int((nf+2)/2) * (wpdn/nf + 0.18u)' nrd='0.18u / wpdn' nrs='0.18u / wpdn' sa=0 sb=0 sd=0 m=1
XM5 OUT OUTB VDDH VDDH pfet_06v0 L=lpup W=wpup nf=1 ad='int((nf+1)/2) * wpup/nf * 0.18u' as='int((nf+2)/2) * wpup/nf * 0.18u' pd='2*int((nf+1)/2) * (wpup/nf + 0.18u)'
+ ps='2*int((nf+2)/2) * (wpup/nf + 0.18u)' nrd='0.18u / wpup' nrs='0.18u / wpup' sa=0 sb=0 sd=0 m=1
XM6 OUTB OUT VDDH VDDH pfet_06v0 L=lpup W=wpup nf=1 ad='int((nf+1)/2) * wpup/nf * 0.18u' as='int((nf+2)/2) * wpup/nf * 0.18u' pd='2*int((nf+1)/2) * (wpup/nf + 0.18u)'
+ ps='2*int((nf+2)/2) * (wpup/nf + 0.18u)' nrd='0.18u / wpup' nrs='0.18u / wpup' sa=0 sb=0 sd=0 m=1
.ends
