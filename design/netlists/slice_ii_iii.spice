* expanding   symbol:  slice_ii_iii.sym # of pins=16
** sym_path: design/array/slice_ii_iii.sym
** sch_path: design/array/slice_ii_iii.sch
.subckt slice_ii_iii RSEL_0 RSEL_1 RSEL_2 RSEL_3 CSEL_20 CSEL_21 CSEL_22 CSEL_23 BLG_II PLG_II BLG_III PLG_III VDDH_II VDDH_III
+ VDDL VSS
*.ipin RSEL_0
*.ipin RSEL_1
*.ipin RSEL_2
*.ipin RSEL_3
*.ipin CSEL_20
*.ipin CSEL_21
*.ipin CSEL_22
*.ipin CSEL_23
*.iopin BLG_II
*.iopin PLG_II
*.iopin BLG_III
*.iopin PLG_III
*.ipin VDDH_II
*.ipin VDDH_III
*.ipin VDDL
*.ipin VSS
Xc_0_20 BL_20 WL_0_II PL_0_II VSS cell_candidate2 wcap=2e-6 lcap=1e-6 wacc=25u lacc=0.60u m=1
Xc_0_21 BL_21 WL_0_II PL_0_II VSS cell_candidate2 wcap=1e-6 lcap=1e-6 wacc=50u lacc=0.60u m=1
Xc_0_22 BL_22 WL_0_III PL_0_III VDDH_III cell_candidate3 wcap=1e-6 lcap=1e-6 wacc=0.30u lacc=0.55u m=1
Xc_0_23 BL_23 WL_0_III PL_0_III VDDH_III cell_candidate3 wcap=2e-6 lcap=1e-6 wacc=0.30u lacc=0.55u m=1
Xc_1_20 BL_20 WL_1_II PL_1_II VSS cell_candidate2 wcap=1e-6 lcap=1e-6 wacc=25u lacc=0.60u m=1
Xc_1_21 BL_21 WL_1_II PL_1_II VSS cell_candidate2 wcap=2e-6 lcap=1e-6 wacc=50u lacc=0.60u m=1
Xc_1_22 BL_22 WL_1_III PL_1_III VDDH_III cell_candidate3 wcap=2e-6 lcap=1e-6 wacc=0.30u lacc=0.55u m=1
Xc_1_23 BL_23 WL_1_III PL_1_III VDDH_III cell_candidate3 wcap=1e-6 lcap=1e-6 wacc=0.30u lacc=0.55u m=1
Xc_2_20 BL_20 WL_2_II PL_2_II VSS cell_candidate2 wcap=2e-6 lcap=1e-6 wacc=50u lacc=0.60u m=1
Xc_2_21 BL_21 WL_2_II PL_2_II VSS cell_candidate2 wcap=1e-6 lcap=1e-6 wacc=25u lacc=0.60u m=1
Xc_2_22 BL_22 WL_2_III PL_2_III VDDH_III cell_candidate3 wcap=1e-6 lcap=1e-6 wacc=0.6u lacc=0.55u m=1
Xc_2_23 BL_23 WL_2_III PL_2_III VDDH_III cell_candidate3 wcap=2e-6 lcap=1e-6 wacc=0.6u lacc=0.55u m=1
Xc_3_20 BL_20 WL_3_II PL_3_II VSS cell_candidate2 wcap=1e-6 lcap=1e-6 wacc=50u lacc=0.60u m=1
Xc_3_21 BL_21 WL_3_II PL_3_II VSS cell_candidate2 wcap=2e-6 lcap=1e-6 wacc=25u lacc=0.60u m=1
Xc_3_22 BL_22 WL_3_III PL_3_III VDDH_III cell_candidate3 wcap=2e-6 lcap=1e-6 wacc=0.6u lacc=0.55u m=1
Xc_3_23 BL_23 WL_3_III PL_3_III VDDH_III cell_candidate3 wcap=1e-6 lcap=1e-6 wacc=0.6u lacc=0.55u m=1
XLC_20 CSEL_20 VDDL VSS CG_20 CGB_20 VDDH_II ls_hv10 wpdn=20u lpdn=0.60u wpup=5u lpup=0.60u
XPC_20 BLG_II CG_20 BL_20 VSS pg_n10 wpg=25u lpg=0.60u
XLC_21 CSEL_21 VDDL VSS CG_21 CGB_21 VDDH_II ls_hv10 wpdn=20u lpdn=0.60u wpup=5u lpup=0.60u
XPC_21 BLG_II CG_21 BL_21 VSS pg_n10 wpg=25u lpg=0.60u
XLC_22 CSEL_22 VDDL VSS CG_22 CGB_22 VDDH_III ls_hv06 wpdn=10u lpdn=0.70u wpup=1u lpup=0.55u
XPC_22 BLG_III CG_22 BL_22 VSS pg_n06 wpg=20u lpg=0.70u
XLC_23 CSEL_23 VDDL VSS CG_23 CGB_23 VDDH_III ls_hv06 wpdn=10u lpdn=0.70u wpup=1u lpup=0.55u
XPC_23 BLG_III CG_23 BL_23 VSS pg_n06 wpg=20u lpg=0.70u
XLR_0_II RSEL_0 VDDL VSS WL_0_II RGB_0_II VDDH_II ls_hv10 wpdn=20u lpdn=0.60u wpup=5u lpup=0.60u
XPR_0_II PL_0_II WL_0_II PLG_II VSS pg_n10 wpg=25u lpg=0.60u
XLR_1_II RSEL_1 VDDL VSS WL_1_II RGB_1_II VDDH_II ls_hv10 wpdn=20u lpdn=0.60u wpup=5u lpup=0.60u
XPR_1_II PL_1_II WL_1_II PLG_II VSS pg_n10 wpg=25u lpg=0.60u
XLR_2_II RSEL_2 VDDL VSS WL_2_II RGB_2_II VDDH_II ls_hv10 wpdn=20u lpdn=0.60u wpup=5u lpup=0.60u
XPR_2_II PL_2_II WL_2_II PLG_II VSS pg_n10 wpg=25u lpg=0.60u
XLR_3_II RSEL_3 VDDL VSS WL_3_II RGB_3_II VDDH_II ls_hv10 wpdn=20u lpdn=0.60u wpup=5u lpup=0.60u
XPR_3_II PL_3_II WL_3_II PLG_II VSS pg_n10 wpg=25u lpg=0.60u
XLR_0_III RSEL_0 VDDL VSS RG_0_III WL_0_III VDDH_III ls_hv06 wpdn=10u lpdn=0.70u wpup=1u lpup=0.55u
XPR_0_III PL_0_III RG_0_III PLG_III VSS pg_n06 wpg=20u lpg=0.70u
XLR_1_III RSEL_1 VDDL VSS RG_1_III WL_1_III VDDH_III ls_hv06 wpdn=10u lpdn=0.70u wpup=1u lpup=0.55u
XPR_1_III PL_1_III RG_1_III PLG_III VSS pg_n06 wpg=20u lpg=0.70u
XLR_2_III RSEL_2 VDDL VSS RG_2_III WL_2_III VDDH_III ls_hv06 wpdn=10u lpdn=0.70u wpup=1u lpup=0.55u
XPR_2_III PL_2_III RG_2_III PLG_III VSS pg_n06 wpg=20u lpg=0.70u
XLR_3_III RSEL_3 VDDL VSS RG_3_III WL_3_III VDDH_III ls_hv06 wpdn=10u lpdn=0.70u wpup=1u lpup=0.55u
XPR_3_III PL_3_III RG_3_III PLG_III VSS pg_n06 wpg=20u lpg=0.70u
.ends
