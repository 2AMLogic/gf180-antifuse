* gf180-antifuse: elaboration + parameter-propagation check, Candidate 2.
*
* NOT a design result and NOT evidence: this deck exists only to prove that
* the xschem-derived netlist design/netlists/cell_candidate2.spice
*   (a) elaborates cleanly in ngspice against the pinned PDK model files, and
*   (b) actually routes the wcap/lcap subcircuit parameters through to the
*       capacitor instance.
* Device characterization, programming-yield and read-margin work belongs in
* sim/ with PVT corners, per CLAUDE.md. Nothing here is cornered.
*
* Run it through design/check-netlists.sh - that script materializes the two
* generated includes this deck expects:
*   models.spice   - the pinned PDK model libraries, path-resolved from PDK_ROOT
*   geometry.spice - .param wcell / lcell, the capacitor geometry under test
*
* PL is driven by the only AC source in the deck and connects to nothing but
* the capacitor's body plate, so mag(i(vpl)) is the capacitor branch current
* alone - no access-device parasitics in the measurement. Doubling the
* capacitor area must double it.
*
* Candidate 2's access device is the 10 V LDNMOS, whose drain-extended
* terminal faces BL by deliberate assignment - see design/cells/
* cell_candidate2.sch. WL sits higher here than in Candidate 1 only to hold
* that device firmly on for the operating point; it is not a program-pulse
* condition and carries no design claim.

.include models.spice
.include cell_candidate2.spice
.include geometry.spice

* Capacitor geometry comes in as subcircuit parameters. Access-device
* geometry is left at the subcircuit's own defaults.
X1 BL WL PL 0 cell_candidate2 wcap=wcell lcap=lcell

* Access device held on so the cell node CN has a defined DC operating point.
VBL BL 0 DC 1.0
VWL WL 0 DC 5.0
VPL PL 0 DC 0 AC 1

.control
op
print v(bl) v(wl) v(x1.cn)
ac lin 1 1e3 1e3
print mag(i(vpl))
.endc
.end
