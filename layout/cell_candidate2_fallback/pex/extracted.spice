* extracted by klt extract --deck gf180mcu
* parasitic model (--parasitics):
* - capacitance: net-to-ground for every net's own (non-coupled) area/perimeter, plus net-to-net for the vertical-overlap coupling `coupling` describes below -- a coupled net pair gets a direct capacitor between their two hub nodes, not just capacitors to the deck's ground/substrate net
* - coupling: vertical overlap (crossover) unconditionally -- where one net's conductor on an adjacent metal level sits directly over another *distinct* net's conductor, that overlap area is charged between the two nets instead of to ground (issue #760) -- plus lateral (same-layer, sidewall) coupling, but only for a net pair naming one of the caller's declared `--critical-net` nets (issue #976): facing-edge length within that layer's own minimum-spacing lookback is charged between the two nets, *additively* (not deducted from either net's substrate fringe term, unlike the vertical case -- a known simplification). Any same-layer pair with neither side named `--critical-net`, and fringe shielding in general, are still not modelled
* - resistance: single lumped series resistance per net, distributed as a star across that net's device terminals (issue #592) -- not a per-segment, distributed RC ladder, *unless* `--distributed-rc` names this net via `--critical-net` (issue #977, Epic #709 Phase 2b): then the net's terminals are ordered along their approximate physical spread and its total R/C is broken into a chain of per-segment resistors (segment length proportional to inter-terminal distance) with a ground capacitor at each terminal node (proportional to its adjacent segment length/2), instead of one star hub -- still an approximation (terminal position is a device-placement proxy, not true per-segment routing geometry), but a strictly finer-grained one than the single-hub star
* - frequency: quasi-static -- one frequency-independent R and C per net; no skin effect, no distributed transmission-line behavior
* - substrate tie: 1e+12 ohm to ground -- the substrate is capacitively floating in transient analysis (DC reference only); see --substrate-tie-ohms
.GLOBAL vsubs

* cell cell_candidate2_fallback
* pin BL
* pin PL_G2X
* pin PL_GMIN
* pin VB
.SUBCKT cell_candidate2_fallback BL PL_G2X PL_GMIN VB
* device instance $1 r0 *1 0.85,0.5 cap_nmos_06v0
X$1 PL_GMIN__t0 BL__t0 cap_nmos_06v0 c_length=1U c_width=0.7U
* device instance $2 r0 *1 5.85,1 cap_nmos_06v0
X$2 PL_G2X__t0 BL__t1 cap_nmos_06v0 c_length=2U c_width=0.7U
* device instance BL_t0 r0 *1 0,0
RBL_t0 BL__t0 BL 1.09735
* device instance BL_t1 r0 *1 0,0
RBL_t1 BL__t1 BL 1.09735
* device instance BL r0 *1 0,0
CBL BL vsubs 1.078085e-15
* device instance PL_G2X_t0 r0 *1 0,0
RPL_G2X_t0 PL_G2X__t0 PL_G2X 41.4522
* device instance PL_G2X r0 *1 0,0
CPL_G2X PL_G2X vsubs 7.2307e-16
* device instance PL_GMIN_t0 r0 *1 0,0
RPL_GMIN_t0 PL_GMIN__t0 PL_GMIN 32.3646
* device instance PL_GMIN r0 *1 0,0
CPL_GMIN PL_GMIN vsubs 5.45601e-16
* device instance VB r0 *1 0,0
RVB VB VB__par 7.04
* device instance VB r0 *1 0,0
CVB VB__par vsubs 2.991001e-15
* device instance vsubs_dctie r0 *1 0,0
Rvsubs_dctie vsubs 0 1e+12
.ENDS cell_candidate2_fallback
