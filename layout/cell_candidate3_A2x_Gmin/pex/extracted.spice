* extracted by klt extract --deck gf180mcu
* parasitic model (--parasitics):
* - capacitance: net-to-ground for every net's own (non-coupled) area/perimeter, plus net-to-net for the vertical-overlap coupling `coupling` describes below -- a coupled net pair gets a direct capacitor between their two hub nodes, not just capacitors to the deck's ground/substrate net
* - coupling: vertical overlap (crossover) unconditionally -- where one net's conductor on an adjacent metal level sits directly over another *distinct* net's conductor, that overlap area is charged between the two nets instead of to ground (issue #760) -- plus lateral (same-layer, sidewall) coupling, but only for a net pair naming one of the caller's declared `--critical-net` nets (issue #976): facing-edge length within that layer's own minimum-spacing lookback is charged between the two nets, *additively* (not deducted from either net's substrate fringe term, unlike the vertical case -- a known simplification). Any same-layer pair with neither side named `--critical-net`, and fringe shielding in general, are still not modelled
* - resistance: single lumped series resistance per net, distributed as a star across that net's device terminals (issue #592) -- not a per-segment, distributed RC ladder, *unless* `--distributed-rc` names this net via `--critical-net` (issue #977, Epic #709 Phase 2b): then the net's terminals are ordered along their approximate physical spread and its total R/C is broken into a chain of per-segment resistors (segment length proportional to inter-terminal distance) with a ground capacitor at each terminal node (proportional to its adjacent segment length/2), instead of one star hub -- still an approximation (terminal position is a device-placement proxy, not true per-segment routing geometry), but a strictly finer-grained one than the single-hub star
* - frequency: quasi-static -- one frequency-independent R and C per net; no skin effect, no distributed transmission-line behavior
* - substrate tie: 1e+12 ohm to ground -- the substrate is capacitively floating in transient analysis (DC reference only); see --substrate-tie-ohms
.GLOBAL vsubs

* cell cell_candidate3_A2x_Gmin
* pin BL
* pin PL
* pin VB
* pin WL
.SUBCKT cell_candidate3_A2x_Gmin BL PL VB WL
* device instance $1 r0 *1 6.23,0.5 cap_pmos_03v3
X$1 \$1__t0 PL__t0 cap_pmos_03v3 c_length=1U c_width=0.28U
* device instance $2 r0 *1 0.775,0.42 pfet
X$2 \$1__t1 WL__t0 BL__t0 VB__t0 pfet_06v0 L=0.55U W=0.84U AS=0.42P AD=0.42P
+ PS=2.68U PD=2.68U
* device instance _1_t0 r0 *1 0,0
R_1_t0 \$1__t0 \$1 30.1578
* device instance _1_t1 r0 *1 0,0
R_1_t1 \$1__t1 \$1 30.1578
* device instance _1 r0 *1 0,0
C_1 \$1 vsubs 1.093713e-15
* device instance BL_t0 r0 *1 0,0
RBL_t0 BL__t0 BL 0.18
* device instance BL r0 *1 0,0
CBL BL vsubs 1.0995e-16
* device instance PL_t0 r0 *1 0,0
RPL_t0 PL__t0 PL 0.6979
* device instance PL r0 *1 0,0
CPL PL vsubs 2.68765e-16
* device instance VB_t0 r0 *1 0,0
RVB_t0 VB__t0 VB 5.8773
* device instance VB r0 *1 0,0
CVB VB vsubs 3.25282e-15
* device instance WL_t0 r0 *1 0,0
RWL_t0 WL__t0 WL 39.491
* device instance WL r0 *1 0,0
CWL WL vsubs 3.98172e-16
* device instance cc__1_VB r0 *1 0,0
Ccc__1_VB \$1 VB 2.4791e-17
* device instance vsubs_dctie r0 *1 0,0
Rvsubs_dctie vsubs 0 1e+12
.ENDS cell_candidate3_A2x_Gmin
