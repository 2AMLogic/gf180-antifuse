* LVS reference for layout/cell_candidate3/cell_candidate3.gds.
* Derived from design/netlists/cell_candidate3.spice (do not edit that file):
* same subcircuit, same device models and connectivity, with the subcircuit's
* parameters (wcap, lcap, wacc, lacc) resolved to the drawn Minimum x Minimum
* geometry point, because klt lvs --reference-form subckt-call cannot carry
* parameter expressions. Only literal geometry differs from the source netlist.
.subckt cell_candidate3 BL WL PL VB
XM1 CN WL BL VB pfet_06v0 L=0.55u W=0.42u nf=1 m=1
XC1 CN PL cap_pmos_03v3 c_width=1.0u c_length=0.28u m=1
.ends
* Drawn Region III split from design/netlists/cell_candidate3.spice.
.subckt cell_candidate3_A2x_G2x BL WL PL VB
XM1 CN WL BL VB pfet_06v0 L=0.55u W=0.84u nf=1 m=1
XC1 CN PL cap_pmos_03v3 c_width=2.0u c_length=0.28u m=1
.ends
* Drawn Region III split from design/netlists/cell_candidate3.spice.
.subckt cell_candidate3_A2x_Gmin BL WL PL VB
XM1 CN WL BL VB pfet_06v0 L=0.55u W=0.84u nf=1 m=1
XC1 CN PL cap_pmos_03v3 c_width=1.0u c_length=0.28u m=1
.ends
* LVS reference for layout/cell_candidate3_Amin_G2x/cell_candidate3_Amin_G2x.gds.
* Derived from design/netlists/cell_candidate3.spice (do not edit that file):
* same subcircuit, same device models and connectivity, with the subcircuit's
* parameters (wcap, lcap, wacc, lacc) resolved to the drawn access Minimum x capacitor 2x
* geometry point, because klt lvs --reference-form subckt-call cannot carry
* parameter expressions. Only literal geometry differs from the source netlist.
.subckt cell_candidate3_Amin_G2x BL WL PL VB
XM1 CN WL BL VB pfet_06v0 L=0.55u W=0.42u nf=1 m=1
XC1 CN PL cap_pmos_03v3 c_width=2.0u c_length=0.28u m=1
.ends
.subckt array_region_iii BL_22 BL_23 BL_24 BL_25 BL_26 BL_27 BL_28 BL_29 BL_30 BL_31 WL_0_III WL_1_III WL_2_III WL_3_III WL_4_III WL_5_III WL_6_III WL_7_III WL_8_III WL_9_III WL_10_III WL_11_III WL_12_III WL_13_III WL_14_III WL_15_III WL_16_III WL_17_III WL_18_III WL_19_III WL_20_III WL_21_III WL_22_III WL_23_III WL_24_III WL_25_III WL_26_III WL_27_III WL_28_III WL_29_III WL_30_III WL_31_III PL_0_III PL_1_III PL_2_III PL_3_III PL_4_III PL_5_III PL_6_III PL_7_III PL_8_III PL_9_III PL_10_III PL_11_III PL_12_III PL_13_III PL_14_III PL_15_III PL_16_III PL_17_III PL_18_III PL_19_III PL_20_III PL_21_III PL_22_III PL_23_III PL_24_III PL_25_III PL_26_III PL_27_III PL_28_III PL_29_III PL_30_III PL_31_III VDDH_III
Xc_0_22 BL_22 WL_0_III PL_0_III VDDH_III cell_candidate3
Xc_0_23 BL_23 WL_0_III PL_0_III VDDH_III cell_candidate3_Amin_G2x
Xc_0_24 BL_24 WL_0_III PL_0_III VDDH_III cell_candidate3_A2x_Gmin
Xc_0_25 BL_25 WL_0_III PL_0_III VDDH_III cell_candidate3_A2x_G2x
Xc_0_26 BL_26 WL_0_III PL_0_III VDDH_III cell_candidate3
Xc_0_27 BL_27 WL_0_III PL_0_III VDDH_III cell_candidate3_Amin_G2x
Xc_0_28 BL_28 WL_0_III PL_0_III VDDH_III cell_candidate3_A2x_Gmin
Xc_0_29 BL_29 WL_0_III PL_0_III VDDH_III cell_candidate3_A2x_G2x
Xc_0_30 BL_30 WL_0_III PL_0_III VDDH_III cell_candidate3
Xc_0_31 BL_31 WL_0_III PL_0_III VDDH_III cell_candidate3_Amin_G2x
Xc_1_22 BL_22 WL_1_III PL_1_III VDDH_III cell_candidate3_Amin_G2x
Xc_1_23 BL_23 WL_1_III PL_1_III VDDH_III cell_candidate3
Xc_1_24 BL_24 WL_1_III PL_1_III VDDH_III cell_candidate3_A2x_G2x
Xc_1_25 BL_25 WL_1_III PL_1_III VDDH_III cell_candidate3_A2x_Gmin
Xc_1_26 BL_26 WL_1_III PL_1_III VDDH_III cell_candidate3_Amin_G2x
Xc_1_27 BL_27 WL_1_III PL_1_III VDDH_III cell_candidate3
Xc_1_28 BL_28 WL_1_III PL_1_III VDDH_III cell_candidate3_A2x_G2x
Xc_1_29 BL_29 WL_1_III PL_1_III VDDH_III cell_candidate3_A2x_Gmin
Xc_1_30 BL_30 WL_1_III PL_1_III VDDH_III cell_candidate3_Amin_G2x
Xc_1_31 BL_31 WL_1_III PL_1_III VDDH_III cell_candidate3
Xc_2_22 BL_22 WL_2_III PL_2_III VDDH_III cell_candidate3_A2x_Gmin
Xc_2_23 BL_23 WL_2_III PL_2_III VDDH_III cell_candidate3_A2x_G2x
Xc_2_24 BL_24 WL_2_III PL_2_III VDDH_III cell_candidate3
Xc_2_25 BL_25 WL_2_III PL_2_III VDDH_III cell_candidate3_Amin_G2x
Xc_2_26 BL_26 WL_2_III PL_2_III VDDH_III cell_candidate3_A2x_Gmin
Xc_2_27 BL_27 WL_2_III PL_2_III VDDH_III cell_candidate3_A2x_G2x
Xc_2_28 BL_28 WL_2_III PL_2_III VDDH_III cell_candidate3
Xc_2_29 BL_29 WL_2_III PL_2_III VDDH_III cell_candidate3_Amin_G2x
Xc_2_30 BL_30 WL_2_III PL_2_III VDDH_III cell_candidate3_A2x_Gmin
Xc_2_31 BL_31 WL_2_III PL_2_III VDDH_III cell_candidate3_A2x_G2x
Xc_3_22 BL_22 WL_3_III PL_3_III VDDH_III cell_candidate3_A2x_G2x
Xc_3_23 BL_23 WL_3_III PL_3_III VDDH_III cell_candidate3_A2x_Gmin
Xc_3_24 BL_24 WL_3_III PL_3_III VDDH_III cell_candidate3_Amin_G2x
Xc_3_25 BL_25 WL_3_III PL_3_III VDDH_III cell_candidate3
Xc_3_26 BL_26 WL_3_III PL_3_III VDDH_III cell_candidate3_A2x_G2x
Xc_3_27 BL_27 WL_3_III PL_3_III VDDH_III cell_candidate3_A2x_Gmin
Xc_3_28 BL_28 WL_3_III PL_3_III VDDH_III cell_candidate3_Amin_G2x
Xc_3_29 BL_29 WL_3_III PL_3_III VDDH_III cell_candidate3
Xc_3_30 BL_30 WL_3_III PL_3_III VDDH_III cell_candidate3_A2x_G2x
Xc_3_31 BL_31 WL_3_III PL_3_III VDDH_III cell_candidate3_A2x_Gmin
Xc_4_22 BL_22 WL_4_III PL_4_III VDDH_III cell_candidate3
Xc_4_23 BL_23 WL_4_III PL_4_III VDDH_III cell_candidate3_Amin_G2x
Xc_4_24 BL_24 WL_4_III PL_4_III VDDH_III cell_candidate3_A2x_Gmin
Xc_4_25 BL_25 WL_4_III PL_4_III VDDH_III cell_candidate3_A2x_G2x
Xc_4_26 BL_26 WL_4_III PL_4_III VDDH_III cell_candidate3
Xc_4_27 BL_27 WL_4_III PL_4_III VDDH_III cell_candidate3_Amin_G2x
Xc_4_28 BL_28 WL_4_III PL_4_III VDDH_III cell_candidate3_A2x_Gmin
Xc_4_29 BL_29 WL_4_III PL_4_III VDDH_III cell_candidate3_A2x_G2x
Xc_4_30 BL_30 WL_4_III PL_4_III VDDH_III cell_candidate3
Xc_4_31 BL_31 WL_4_III PL_4_III VDDH_III cell_candidate3_Amin_G2x
Xc_5_22 BL_22 WL_5_III PL_5_III VDDH_III cell_candidate3_Amin_G2x
Xc_5_23 BL_23 WL_5_III PL_5_III VDDH_III cell_candidate3
Xc_5_24 BL_24 WL_5_III PL_5_III VDDH_III cell_candidate3_A2x_G2x
Xc_5_25 BL_25 WL_5_III PL_5_III VDDH_III cell_candidate3_A2x_Gmin
Xc_5_26 BL_26 WL_5_III PL_5_III VDDH_III cell_candidate3_Amin_G2x
Xc_5_27 BL_27 WL_5_III PL_5_III VDDH_III cell_candidate3
Xc_5_28 BL_28 WL_5_III PL_5_III VDDH_III cell_candidate3_A2x_G2x
Xc_5_29 BL_29 WL_5_III PL_5_III VDDH_III cell_candidate3_A2x_Gmin
Xc_5_30 BL_30 WL_5_III PL_5_III VDDH_III cell_candidate3_Amin_G2x
Xc_5_31 BL_31 WL_5_III PL_5_III VDDH_III cell_candidate3
Xc_6_22 BL_22 WL_6_III PL_6_III VDDH_III cell_candidate3_A2x_Gmin
Xc_6_23 BL_23 WL_6_III PL_6_III VDDH_III cell_candidate3_A2x_G2x
Xc_6_24 BL_24 WL_6_III PL_6_III VDDH_III cell_candidate3
Xc_6_25 BL_25 WL_6_III PL_6_III VDDH_III cell_candidate3_Amin_G2x
Xc_6_26 BL_26 WL_6_III PL_6_III VDDH_III cell_candidate3_A2x_Gmin
Xc_6_27 BL_27 WL_6_III PL_6_III VDDH_III cell_candidate3_A2x_G2x
Xc_6_28 BL_28 WL_6_III PL_6_III VDDH_III cell_candidate3
Xc_6_29 BL_29 WL_6_III PL_6_III VDDH_III cell_candidate3_Amin_G2x
Xc_6_30 BL_30 WL_6_III PL_6_III VDDH_III cell_candidate3_A2x_Gmin
Xc_6_31 BL_31 WL_6_III PL_6_III VDDH_III cell_candidate3_A2x_G2x
Xc_7_22 BL_22 WL_7_III PL_7_III VDDH_III cell_candidate3_A2x_G2x
Xc_7_23 BL_23 WL_7_III PL_7_III VDDH_III cell_candidate3_A2x_Gmin
Xc_7_24 BL_24 WL_7_III PL_7_III VDDH_III cell_candidate3_Amin_G2x
Xc_7_25 BL_25 WL_7_III PL_7_III VDDH_III cell_candidate3
Xc_7_26 BL_26 WL_7_III PL_7_III VDDH_III cell_candidate3_A2x_G2x
Xc_7_27 BL_27 WL_7_III PL_7_III VDDH_III cell_candidate3_A2x_Gmin
Xc_7_28 BL_28 WL_7_III PL_7_III VDDH_III cell_candidate3_Amin_G2x
Xc_7_29 BL_29 WL_7_III PL_7_III VDDH_III cell_candidate3
Xc_7_30 BL_30 WL_7_III PL_7_III VDDH_III cell_candidate3_A2x_G2x
Xc_7_31 BL_31 WL_7_III PL_7_III VDDH_III cell_candidate3_A2x_Gmin
Xc_8_22 BL_22 WL_8_III PL_8_III VDDH_III cell_candidate3
Xc_8_23 BL_23 WL_8_III PL_8_III VDDH_III cell_candidate3_Amin_G2x
Xc_8_24 BL_24 WL_8_III PL_8_III VDDH_III cell_candidate3_A2x_Gmin
Xc_8_25 BL_25 WL_8_III PL_8_III VDDH_III cell_candidate3_A2x_G2x
Xc_8_26 BL_26 WL_8_III PL_8_III VDDH_III cell_candidate3
Xc_8_27 BL_27 WL_8_III PL_8_III VDDH_III cell_candidate3_Amin_G2x
Xc_8_28 BL_28 WL_8_III PL_8_III VDDH_III cell_candidate3_A2x_Gmin
Xc_8_29 BL_29 WL_8_III PL_8_III VDDH_III cell_candidate3_A2x_G2x
Xc_8_30 BL_30 WL_8_III PL_8_III VDDH_III cell_candidate3
Xc_8_31 BL_31 WL_8_III PL_8_III VDDH_III cell_candidate3_Amin_G2x
Xc_9_22 BL_22 WL_9_III PL_9_III VDDH_III cell_candidate3_Amin_G2x
Xc_9_23 BL_23 WL_9_III PL_9_III VDDH_III cell_candidate3
Xc_9_24 BL_24 WL_9_III PL_9_III VDDH_III cell_candidate3_A2x_G2x
Xc_9_25 BL_25 WL_9_III PL_9_III VDDH_III cell_candidate3_A2x_Gmin
Xc_9_26 BL_26 WL_9_III PL_9_III VDDH_III cell_candidate3_Amin_G2x
Xc_9_27 BL_27 WL_9_III PL_9_III VDDH_III cell_candidate3
Xc_9_28 BL_28 WL_9_III PL_9_III VDDH_III cell_candidate3_A2x_G2x
Xc_9_29 BL_29 WL_9_III PL_9_III VDDH_III cell_candidate3_A2x_Gmin
Xc_9_30 BL_30 WL_9_III PL_9_III VDDH_III cell_candidate3_Amin_G2x
Xc_9_31 BL_31 WL_9_III PL_9_III VDDH_III cell_candidate3
Xc_10_22 BL_22 WL_10_III PL_10_III VDDH_III cell_candidate3_A2x_Gmin
Xc_10_23 BL_23 WL_10_III PL_10_III VDDH_III cell_candidate3_A2x_G2x
Xc_10_24 BL_24 WL_10_III PL_10_III VDDH_III cell_candidate3
Xc_10_25 BL_25 WL_10_III PL_10_III VDDH_III cell_candidate3_Amin_G2x
Xc_10_26 BL_26 WL_10_III PL_10_III VDDH_III cell_candidate3_A2x_Gmin
Xc_10_27 BL_27 WL_10_III PL_10_III VDDH_III cell_candidate3_A2x_G2x
Xc_10_28 BL_28 WL_10_III PL_10_III VDDH_III cell_candidate3
Xc_10_29 BL_29 WL_10_III PL_10_III VDDH_III cell_candidate3_Amin_G2x
Xc_10_30 BL_30 WL_10_III PL_10_III VDDH_III cell_candidate3_A2x_Gmin
Xc_10_31 BL_31 WL_10_III PL_10_III VDDH_III cell_candidate3_A2x_G2x
Xc_11_22 BL_22 WL_11_III PL_11_III VDDH_III cell_candidate3_A2x_G2x
Xc_11_23 BL_23 WL_11_III PL_11_III VDDH_III cell_candidate3_A2x_Gmin
Xc_11_24 BL_24 WL_11_III PL_11_III VDDH_III cell_candidate3_Amin_G2x
Xc_11_25 BL_25 WL_11_III PL_11_III VDDH_III cell_candidate3
Xc_11_26 BL_26 WL_11_III PL_11_III VDDH_III cell_candidate3_A2x_G2x
Xc_11_27 BL_27 WL_11_III PL_11_III VDDH_III cell_candidate3_A2x_Gmin
Xc_11_28 BL_28 WL_11_III PL_11_III VDDH_III cell_candidate3_Amin_G2x
Xc_11_29 BL_29 WL_11_III PL_11_III VDDH_III cell_candidate3
Xc_11_30 BL_30 WL_11_III PL_11_III VDDH_III cell_candidate3_A2x_G2x
Xc_11_31 BL_31 WL_11_III PL_11_III VDDH_III cell_candidate3_A2x_Gmin
Xc_12_22 BL_22 WL_12_III PL_12_III VDDH_III cell_candidate3
Xc_12_23 BL_23 WL_12_III PL_12_III VDDH_III cell_candidate3_Amin_G2x
Xc_12_24 BL_24 WL_12_III PL_12_III VDDH_III cell_candidate3_A2x_Gmin
Xc_12_25 BL_25 WL_12_III PL_12_III VDDH_III cell_candidate3_A2x_G2x
Xc_12_26 BL_26 WL_12_III PL_12_III VDDH_III cell_candidate3
Xc_12_27 BL_27 WL_12_III PL_12_III VDDH_III cell_candidate3_Amin_G2x
Xc_12_28 BL_28 WL_12_III PL_12_III VDDH_III cell_candidate3_A2x_Gmin
Xc_12_29 BL_29 WL_12_III PL_12_III VDDH_III cell_candidate3_A2x_G2x
Xc_12_30 BL_30 WL_12_III PL_12_III VDDH_III cell_candidate3
Xc_12_31 BL_31 WL_12_III PL_12_III VDDH_III cell_candidate3_Amin_G2x
Xc_13_22 BL_22 WL_13_III PL_13_III VDDH_III cell_candidate3_Amin_G2x
Xc_13_23 BL_23 WL_13_III PL_13_III VDDH_III cell_candidate3
Xc_13_24 BL_24 WL_13_III PL_13_III VDDH_III cell_candidate3_A2x_G2x
Xc_13_25 BL_25 WL_13_III PL_13_III VDDH_III cell_candidate3_A2x_Gmin
Xc_13_26 BL_26 WL_13_III PL_13_III VDDH_III cell_candidate3_Amin_G2x
Xc_13_27 BL_27 WL_13_III PL_13_III VDDH_III cell_candidate3
Xc_13_28 BL_28 WL_13_III PL_13_III VDDH_III cell_candidate3_A2x_G2x
Xc_13_29 BL_29 WL_13_III PL_13_III VDDH_III cell_candidate3_A2x_Gmin
Xc_13_30 BL_30 WL_13_III PL_13_III VDDH_III cell_candidate3_Amin_G2x
Xc_13_31 BL_31 WL_13_III PL_13_III VDDH_III cell_candidate3
Xc_14_22 BL_22 WL_14_III PL_14_III VDDH_III cell_candidate3_A2x_Gmin
Xc_14_23 BL_23 WL_14_III PL_14_III VDDH_III cell_candidate3_A2x_G2x
Xc_14_24 BL_24 WL_14_III PL_14_III VDDH_III cell_candidate3
Xc_14_25 BL_25 WL_14_III PL_14_III VDDH_III cell_candidate3_Amin_G2x
Xc_14_26 BL_26 WL_14_III PL_14_III VDDH_III cell_candidate3_A2x_Gmin
Xc_14_27 BL_27 WL_14_III PL_14_III VDDH_III cell_candidate3_A2x_G2x
Xc_14_28 BL_28 WL_14_III PL_14_III VDDH_III cell_candidate3
Xc_14_29 BL_29 WL_14_III PL_14_III VDDH_III cell_candidate3_Amin_G2x
Xc_14_30 BL_30 WL_14_III PL_14_III VDDH_III cell_candidate3_A2x_Gmin
Xc_14_31 BL_31 WL_14_III PL_14_III VDDH_III cell_candidate3_A2x_G2x
Xc_15_22 BL_22 WL_15_III PL_15_III VDDH_III cell_candidate3_A2x_G2x
Xc_15_23 BL_23 WL_15_III PL_15_III VDDH_III cell_candidate3_A2x_Gmin
Xc_15_24 BL_24 WL_15_III PL_15_III VDDH_III cell_candidate3_Amin_G2x
Xc_15_25 BL_25 WL_15_III PL_15_III VDDH_III cell_candidate3
Xc_15_26 BL_26 WL_15_III PL_15_III VDDH_III cell_candidate3_A2x_G2x
Xc_15_27 BL_27 WL_15_III PL_15_III VDDH_III cell_candidate3_A2x_Gmin
Xc_15_28 BL_28 WL_15_III PL_15_III VDDH_III cell_candidate3_Amin_G2x
Xc_15_29 BL_29 WL_15_III PL_15_III VDDH_III cell_candidate3
Xc_15_30 BL_30 WL_15_III PL_15_III VDDH_III cell_candidate3_A2x_G2x
Xc_15_31 BL_31 WL_15_III PL_15_III VDDH_III cell_candidate3_A2x_Gmin
Xc_16_22 BL_22 WL_16_III PL_16_III VDDH_III cell_candidate3
Xc_16_23 BL_23 WL_16_III PL_16_III VDDH_III cell_candidate3_Amin_G2x
Xc_16_24 BL_24 WL_16_III PL_16_III VDDH_III cell_candidate3_A2x_Gmin
Xc_16_25 BL_25 WL_16_III PL_16_III VDDH_III cell_candidate3_A2x_G2x
Xc_16_26 BL_26 WL_16_III PL_16_III VDDH_III cell_candidate3
Xc_16_27 BL_27 WL_16_III PL_16_III VDDH_III cell_candidate3_Amin_G2x
Xc_16_28 BL_28 WL_16_III PL_16_III VDDH_III cell_candidate3_A2x_Gmin
Xc_16_29 BL_29 WL_16_III PL_16_III VDDH_III cell_candidate3_A2x_G2x
Xc_16_30 BL_30 WL_16_III PL_16_III VDDH_III cell_candidate3
Xc_16_31 BL_31 WL_16_III PL_16_III VDDH_III cell_candidate3_Amin_G2x
Xc_17_22 BL_22 WL_17_III PL_17_III VDDH_III cell_candidate3_Amin_G2x
Xc_17_23 BL_23 WL_17_III PL_17_III VDDH_III cell_candidate3
Xc_17_24 BL_24 WL_17_III PL_17_III VDDH_III cell_candidate3_A2x_G2x
Xc_17_25 BL_25 WL_17_III PL_17_III VDDH_III cell_candidate3_A2x_Gmin
Xc_17_26 BL_26 WL_17_III PL_17_III VDDH_III cell_candidate3_Amin_G2x
Xc_17_27 BL_27 WL_17_III PL_17_III VDDH_III cell_candidate3
Xc_17_28 BL_28 WL_17_III PL_17_III VDDH_III cell_candidate3_A2x_G2x
Xc_17_29 BL_29 WL_17_III PL_17_III VDDH_III cell_candidate3_A2x_Gmin
Xc_17_30 BL_30 WL_17_III PL_17_III VDDH_III cell_candidate3_Amin_G2x
Xc_17_31 BL_31 WL_17_III PL_17_III VDDH_III cell_candidate3
Xc_18_22 BL_22 WL_18_III PL_18_III VDDH_III cell_candidate3_A2x_Gmin
Xc_18_23 BL_23 WL_18_III PL_18_III VDDH_III cell_candidate3_A2x_G2x
Xc_18_24 BL_24 WL_18_III PL_18_III VDDH_III cell_candidate3
Xc_18_25 BL_25 WL_18_III PL_18_III VDDH_III cell_candidate3_Amin_G2x
Xc_18_26 BL_26 WL_18_III PL_18_III VDDH_III cell_candidate3_A2x_Gmin
Xc_18_27 BL_27 WL_18_III PL_18_III VDDH_III cell_candidate3_A2x_G2x
Xc_18_28 BL_28 WL_18_III PL_18_III VDDH_III cell_candidate3
Xc_18_29 BL_29 WL_18_III PL_18_III VDDH_III cell_candidate3_Amin_G2x
Xc_18_30 BL_30 WL_18_III PL_18_III VDDH_III cell_candidate3_A2x_Gmin
Xc_18_31 BL_31 WL_18_III PL_18_III VDDH_III cell_candidate3_A2x_G2x
Xc_19_22 BL_22 WL_19_III PL_19_III VDDH_III cell_candidate3_A2x_G2x
Xc_19_23 BL_23 WL_19_III PL_19_III VDDH_III cell_candidate3_A2x_Gmin
Xc_19_24 BL_24 WL_19_III PL_19_III VDDH_III cell_candidate3_Amin_G2x
Xc_19_25 BL_25 WL_19_III PL_19_III VDDH_III cell_candidate3
Xc_19_26 BL_26 WL_19_III PL_19_III VDDH_III cell_candidate3_A2x_G2x
Xc_19_27 BL_27 WL_19_III PL_19_III VDDH_III cell_candidate3_A2x_Gmin
Xc_19_28 BL_28 WL_19_III PL_19_III VDDH_III cell_candidate3_Amin_G2x
Xc_19_29 BL_29 WL_19_III PL_19_III VDDH_III cell_candidate3
Xc_19_30 BL_30 WL_19_III PL_19_III VDDH_III cell_candidate3_A2x_G2x
Xc_19_31 BL_31 WL_19_III PL_19_III VDDH_III cell_candidate3_A2x_Gmin
Xc_20_22 BL_22 WL_20_III PL_20_III VDDH_III cell_candidate3
Xc_20_23 BL_23 WL_20_III PL_20_III VDDH_III cell_candidate3_Amin_G2x
Xc_20_24 BL_24 WL_20_III PL_20_III VDDH_III cell_candidate3_A2x_Gmin
Xc_20_25 BL_25 WL_20_III PL_20_III VDDH_III cell_candidate3_A2x_G2x
Xc_20_26 BL_26 WL_20_III PL_20_III VDDH_III cell_candidate3
Xc_20_27 BL_27 WL_20_III PL_20_III VDDH_III cell_candidate3_Amin_G2x
Xc_20_28 BL_28 WL_20_III PL_20_III VDDH_III cell_candidate3_A2x_Gmin
Xc_20_29 BL_29 WL_20_III PL_20_III VDDH_III cell_candidate3_A2x_G2x
Xc_20_30 BL_30 WL_20_III PL_20_III VDDH_III cell_candidate3
Xc_20_31 BL_31 WL_20_III PL_20_III VDDH_III cell_candidate3_Amin_G2x
Xc_21_22 BL_22 WL_21_III PL_21_III VDDH_III cell_candidate3_Amin_G2x
Xc_21_23 BL_23 WL_21_III PL_21_III VDDH_III cell_candidate3
Xc_21_24 BL_24 WL_21_III PL_21_III VDDH_III cell_candidate3_A2x_G2x
Xc_21_25 BL_25 WL_21_III PL_21_III VDDH_III cell_candidate3_A2x_Gmin
Xc_21_26 BL_26 WL_21_III PL_21_III VDDH_III cell_candidate3_Amin_G2x
Xc_21_27 BL_27 WL_21_III PL_21_III VDDH_III cell_candidate3
Xc_21_28 BL_28 WL_21_III PL_21_III VDDH_III cell_candidate3_A2x_G2x
Xc_21_29 BL_29 WL_21_III PL_21_III VDDH_III cell_candidate3_A2x_Gmin
Xc_21_30 BL_30 WL_21_III PL_21_III VDDH_III cell_candidate3_Amin_G2x
Xc_21_31 BL_31 WL_21_III PL_21_III VDDH_III cell_candidate3
Xc_22_22 BL_22 WL_22_III PL_22_III VDDH_III cell_candidate3_A2x_Gmin
Xc_22_23 BL_23 WL_22_III PL_22_III VDDH_III cell_candidate3_A2x_G2x
Xc_22_24 BL_24 WL_22_III PL_22_III VDDH_III cell_candidate3
Xc_22_25 BL_25 WL_22_III PL_22_III VDDH_III cell_candidate3_Amin_G2x
Xc_22_26 BL_26 WL_22_III PL_22_III VDDH_III cell_candidate3_A2x_Gmin
Xc_22_27 BL_27 WL_22_III PL_22_III VDDH_III cell_candidate3_A2x_G2x
Xc_22_28 BL_28 WL_22_III PL_22_III VDDH_III cell_candidate3
Xc_22_29 BL_29 WL_22_III PL_22_III VDDH_III cell_candidate3_Amin_G2x
Xc_22_30 BL_30 WL_22_III PL_22_III VDDH_III cell_candidate3_A2x_Gmin
Xc_22_31 BL_31 WL_22_III PL_22_III VDDH_III cell_candidate3_A2x_G2x
Xc_23_22 BL_22 WL_23_III PL_23_III VDDH_III cell_candidate3_A2x_G2x
Xc_23_23 BL_23 WL_23_III PL_23_III VDDH_III cell_candidate3_A2x_Gmin
Xc_23_24 BL_24 WL_23_III PL_23_III VDDH_III cell_candidate3_Amin_G2x
Xc_23_25 BL_25 WL_23_III PL_23_III VDDH_III cell_candidate3
Xc_23_26 BL_26 WL_23_III PL_23_III VDDH_III cell_candidate3_A2x_G2x
Xc_23_27 BL_27 WL_23_III PL_23_III VDDH_III cell_candidate3_A2x_Gmin
Xc_23_28 BL_28 WL_23_III PL_23_III VDDH_III cell_candidate3_Amin_G2x
Xc_23_29 BL_29 WL_23_III PL_23_III VDDH_III cell_candidate3
Xc_23_30 BL_30 WL_23_III PL_23_III VDDH_III cell_candidate3_A2x_G2x
Xc_23_31 BL_31 WL_23_III PL_23_III VDDH_III cell_candidate3_A2x_Gmin
Xc_24_22 BL_22 WL_24_III PL_24_III VDDH_III cell_candidate3
Xc_24_23 BL_23 WL_24_III PL_24_III VDDH_III cell_candidate3_Amin_G2x
Xc_24_24 BL_24 WL_24_III PL_24_III VDDH_III cell_candidate3_A2x_Gmin
Xc_24_25 BL_25 WL_24_III PL_24_III VDDH_III cell_candidate3_A2x_G2x
Xc_24_26 BL_26 WL_24_III PL_24_III VDDH_III cell_candidate3
Xc_24_27 BL_27 WL_24_III PL_24_III VDDH_III cell_candidate3_Amin_G2x
Xc_24_28 BL_28 WL_24_III PL_24_III VDDH_III cell_candidate3_A2x_Gmin
Xc_24_29 BL_29 WL_24_III PL_24_III VDDH_III cell_candidate3_A2x_G2x
Xc_24_30 BL_30 WL_24_III PL_24_III VDDH_III cell_candidate3
Xc_24_31 BL_31 WL_24_III PL_24_III VDDH_III cell_candidate3_Amin_G2x
Xc_25_22 BL_22 WL_25_III PL_25_III VDDH_III cell_candidate3_Amin_G2x
Xc_25_23 BL_23 WL_25_III PL_25_III VDDH_III cell_candidate3
Xc_25_24 BL_24 WL_25_III PL_25_III VDDH_III cell_candidate3_A2x_G2x
Xc_25_25 BL_25 WL_25_III PL_25_III VDDH_III cell_candidate3_A2x_Gmin
Xc_25_26 BL_26 WL_25_III PL_25_III VDDH_III cell_candidate3_Amin_G2x
Xc_25_27 BL_27 WL_25_III PL_25_III VDDH_III cell_candidate3
Xc_25_28 BL_28 WL_25_III PL_25_III VDDH_III cell_candidate3_A2x_G2x
Xc_25_29 BL_29 WL_25_III PL_25_III VDDH_III cell_candidate3_A2x_Gmin
Xc_25_30 BL_30 WL_25_III PL_25_III VDDH_III cell_candidate3_Amin_G2x
Xc_25_31 BL_31 WL_25_III PL_25_III VDDH_III cell_candidate3
Xc_26_22 BL_22 WL_26_III PL_26_III VDDH_III cell_candidate3_A2x_Gmin
Xc_26_23 BL_23 WL_26_III PL_26_III VDDH_III cell_candidate3_A2x_G2x
Xc_26_24 BL_24 WL_26_III PL_26_III VDDH_III cell_candidate3
Xc_26_25 BL_25 WL_26_III PL_26_III VDDH_III cell_candidate3_Amin_G2x
Xc_26_26 BL_26 WL_26_III PL_26_III VDDH_III cell_candidate3_A2x_Gmin
Xc_26_27 BL_27 WL_26_III PL_26_III VDDH_III cell_candidate3_A2x_G2x
Xc_26_28 BL_28 WL_26_III PL_26_III VDDH_III cell_candidate3
Xc_26_29 BL_29 WL_26_III PL_26_III VDDH_III cell_candidate3_Amin_G2x
Xc_26_30 BL_30 WL_26_III PL_26_III VDDH_III cell_candidate3_A2x_Gmin
Xc_26_31 BL_31 WL_26_III PL_26_III VDDH_III cell_candidate3_A2x_G2x
Xc_27_22 BL_22 WL_27_III PL_27_III VDDH_III cell_candidate3_A2x_G2x
Xc_27_23 BL_23 WL_27_III PL_27_III VDDH_III cell_candidate3_A2x_Gmin
Xc_27_24 BL_24 WL_27_III PL_27_III VDDH_III cell_candidate3_Amin_G2x
Xc_27_25 BL_25 WL_27_III PL_27_III VDDH_III cell_candidate3
Xc_27_26 BL_26 WL_27_III PL_27_III VDDH_III cell_candidate3_A2x_G2x
Xc_27_27 BL_27 WL_27_III PL_27_III VDDH_III cell_candidate3_A2x_Gmin
Xc_27_28 BL_28 WL_27_III PL_27_III VDDH_III cell_candidate3_Amin_G2x
Xc_27_29 BL_29 WL_27_III PL_27_III VDDH_III cell_candidate3
Xc_27_30 BL_30 WL_27_III PL_27_III VDDH_III cell_candidate3_A2x_G2x
Xc_27_31 BL_31 WL_27_III PL_27_III VDDH_III cell_candidate3_A2x_Gmin
Xc_28_22 BL_22 WL_28_III PL_28_III VDDH_III cell_candidate3
Xc_28_23 BL_23 WL_28_III PL_28_III VDDH_III cell_candidate3_Amin_G2x
Xc_28_24 BL_24 WL_28_III PL_28_III VDDH_III cell_candidate3_A2x_Gmin
Xc_28_25 BL_25 WL_28_III PL_28_III VDDH_III cell_candidate3_A2x_G2x
Xc_28_26 BL_26 WL_28_III PL_28_III VDDH_III cell_candidate3
Xc_28_27 BL_27 WL_28_III PL_28_III VDDH_III cell_candidate3_Amin_G2x
Xc_28_28 BL_28 WL_28_III PL_28_III VDDH_III cell_candidate3_A2x_Gmin
Xc_28_29 BL_29 WL_28_III PL_28_III VDDH_III cell_candidate3_A2x_G2x
Xc_28_30 BL_30 WL_28_III PL_28_III VDDH_III cell_candidate3
Xc_28_31 BL_31 WL_28_III PL_28_III VDDH_III cell_candidate3_Amin_G2x
Xc_29_22 BL_22 WL_29_III PL_29_III VDDH_III cell_candidate3_Amin_G2x
Xc_29_23 BL_23 WL_29_III PL_29_III VDDH_III cell_candidate3
Xc_29_24 BL_24 WL_29_III PL_29_III VDDH_III cell_candidate3_A2x_G2x
Xc_29_25 BL_25 WL_29_III PL_29_III VDDH_III cell_candidate3_A2x_Gmin
Xc_29_26 BL_26 WL_29_III PL_29_III VDDH_III cell_candidate3_Amin_G2x
Xc_29_27 BL_27 WL_29_III PL_29_III VDDH_III cell_candidate3
Xc_29_28 BL_28 WL_29_III PL_29_III VDDH_III cell_candidate3_A2x_G2x
Xc_29_29 BL_29 WL_29_III PL_29_III VDDH_III cell_candidate3_A2x_Gmin
Xc_29_30 BL_30 WL_29_III PL_29_III VDDH_III cell_candidate3_Amin_G2x
Xc_29_31 BL_31 WL_29_III PL_29_III VDDH_III cell_candidate3
Xc_30_22 BL_22 WL_30_III PL_30_III VDDH_III cell_candidate3_A2x_Gmin
Xc_30_23 BL_23 WL_30_III PL_30_III VDDH_III cell_candidate3_A2x_G2x
Xc_30_24 BL_24 WL_30_III PL_30_III VDDH_III cell_candidate3
Xc_30_25 BL_25 WL_30_III PL_30_III VDDH_III cell_candidate3_Amin_G2x
Xc_30_26 BL_26 WL_30_III PL_30_III VDDH_III cell_candidate3_A2x_Gmin
Xc_30_27 BL_27 WL_30_III PL_30_III VDDH_III cell_candidate3_A2x_G2x
Xc_30_28 BL_28 WL_30_III PL_30_III VDDH_III cell_candidate3
Xc_30_29 BL_29 WL_30_III PL_30_III VDDH_III cell_candidate3_Amin_G2x
Xc_30_30 BL_30 WL_30_III PL_30_III VDDH_III cell_candidate3_A2x_Gmin
Xc_30_31 BL_31 WL_30_III PL_30_III VDDH_III cell_candidate3_A2x_G2x
Xc_31_22 BL_22 WL_31_III PL_31_III VDDH_III cell_candidate3_A2x_G2x
Xc_31_23 BL_23 WL_31_III PL_31_III VDDH_III cell_candidate3_A2x_Gmin
Xc_31_24 BL_24 WL_31_III PL_31_III VDDH_III cell_candidate3_Amin_G2x
Xc_31_25 BL_25 WL_31_III PL_31_III VDDH_III cell_candidate3
Xc_31_26 BL_26 WL_31_III PL_31_III VDDH_III cell_candidate3_A2x_G2x
Xc_31_27 BL_27 WL_31_III PL_31_III VDDH_III cell_candidate3_A2x_Gmin
Xc_31_28 BL_28 WL_31_III PL_31_III VDDH_III cell_candidate3_Amin_G2x
Xc_31_29 BL_29 WL_31_III PL_31_III VDDH_III cell_candidate3
Xc_31_30 BL_30 WL_31_III PL_31_III VDDH_III cell_candidate3_A2x_G2x
Xc_31_31 BL_31 WL_31_III PL_31_III VDDH_III cell_candidate3_A2x_Gmin
.ends
