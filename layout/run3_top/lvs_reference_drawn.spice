* LVS reference for layout/run3_top/run3_top.gds -- DERIVED, do not edit.
* Generated by layout/run3_top/assemble_run3_top.py from the #275
* generator's tables (import generate_run3_top), restricted to the
* instances this assembly can place:
*
*   excluded (no drawn cell, {'cell_candidate2_Amin_G2x'}, #296/#299):
*     Xinst_C2_Amin_G2x_1  pad L22  port PL_C2_Amin_G2x_1
*     Xinst_C2_Amin_G2x_2  pad L23  port PL_C2_Amin_G2x_2
*     Xinst_C2_Amin_G2x_3  pad L24  port PL_C2_Amin_G2x_3
*     Xinst_C2_Amin_G2x_4  pad L25  port PL_C2_Amin_G2x_4
*     Xinst_C2_Amin_G2x_5  pad L26  port PL_C2_Amin_G2x_5
*   their five private-plate ports are excluded with them; every
*   other port and instance of run3_top.spice is present. A full
*   36-instance match is blocked until that cell is drawn.
*
* The substrate net VSS_ANALOG is the #275 generator's
* placeholder (spec/supply-domains-decision.md rows 2/13/14); here it
* is the on-die strap tying the C1/C2 body taps, left internal.

* ---- per-geometry cell subcircuits (7 drawn points) ----

.subckt cell_candidate1 BL WL PL VB
* access: drawn XM1 literal (layout/cell_candidate1/lvs_reference.spice)
XM1 BL WL CN VB nfet_06v0 L=0.70u W=0.42u nf=1 m=1
* capacitor: ratified Gmin level (spec/capacitor-geometry-decision.md)
XC1 CN PL cap_nmos_03v3 c_width=1.0u c_length=0.28u m=1
.ends

.subckt cell_candidate1_Amin_G2x BL WL PL VB
* access: drawn XM1 literal (layout/cell_candidate1_Amin_G2x/lvs_reference.spice)
XM1 BL WL CN VB nfet_06v0 L=0.70u W=0.42u nf=1 m=1
* capacitor: ratified G2x level (spec/capacitor-geometry-decision.md)
XC1 CN PL cap_nmos_03v3 c_width=2.0u c_length=0.28u m=1
.ends

.subckt cell_candidate1_A2x_Gmin BL WL PL VB
* access: drawn XM1 literal (layout/cell_candidate1_A2x_Gmin/lvs_reference.spice)
XM1 BL WL CN VB nfet_06v0 L=0.70u W=0.84u nf=1 m=1
* capacitor: ratified Gmin level (spec/capacitor-geometry-decision.md)
XC1 CN PL cap_nmos_03v3 c_width=1.0u c_length=0.28u m=1
.ends

.subckt cell_candidate1_A2x_G2x BL WL PL VB
* access: drawn XM1 literal (layout/cell_candidate1_A2x_G2x/lvs_reference.spice)
XM1 BL WL CN VB nfet_06v0 L=0.70u W=0.84u nf=1 m=1
* capacitor: ratified G2x level (spec/capacitor-geometry-decision.md)
XC1 CN PL cap_nmos_03v3 c_width=2.0u c_length=0.28u m=1
.ends

.subckt cell_candidate2 BL WL PL VB
* access: drawn XM1 literal (layout/cell_candidate2/lvs_reference.spice)
XM1 BL WL CN VB nfet_10v0_asym L=0.60u W=8u nf=2 m=1
* capacitor: ratified Gmin level (spec/capacitor-geometry-decision.md)
XC1 CN PL cap_nmos_06v0 c_width=1.0u c_length=0.70u m=1
.ends

.subckt cell_candidate3 BL WL PL VB
* access: drawn XM1 literal (layout/cell_candidate3/lvs_reference.spice)
XM1 CN WL BL VB pfet_06v0 L=0.55u W=0.42u nf=1 m=1
* capacitor: ratified Gmin level (spec/capacitor-geometry-decision.md)
XC1 CN PL cap_pmos_03v3 c_width=1.0u c_length=0.28u m=1
.ends

.subckt cell_candidate3_Amin_G2x BL WL PL VB
* access: drawn XM1 literal (layout/cell_candidate3_Amin_G2x/lvs_reference.spice)
XM1 CN WL BL VB pfet_06v0 L=0.55u W=0.42u nf=1 m=1
* capacitor: ratified G2x level (spec/capacitor-geometry-decision.md)
XC1 CN PL cap_pmos_03v3 c_width=2.0u c_length=0.28u m=1
.ends

* ---- top: 31 placed instances, 40 connected ports ----

.subckt run3_top PL_C1_Amin_Gmin_1 PL_C1_Amin_Gmin_2 PL_C1_Amin_Gmin_3 PL_C1_Amin_Gmin_4 PL_C1_Amin_G2x_1 PL_C1_Amin_G2x_2 PL_C1_Amin_G2x_3 PL_C1_Amin_G2x_4 PL_C1_A2x_Gmin_1 PL_C1_A2x_Gmin_2 PL_C1_A2x_Gmin_3 PL_C1_A2x_Gmin_4 PL_C1_A2x_G2x_1 PL_C1_A2x_G2x_2 PL_C1_A2x_G2x_3 PL_C1_A2x_G2x_4 PL_C2_Amin_Gmin_1 PL_C2_Amin_Gmin_2 PL_C2_Amin_Gmin_3 PL_C2_Amin_Gmin_4 PL_C2_Amin_Gmin_5 PL_C3_Amin_Gmin_1 PL_C3_Amin_Gmin_2 PL_C3_Amin_Gmin_3 PL_C3_Amin_Gmin_4 PL_C3_Amin_Gmin_5 PL_C3_Amin_G2x_1 PL_C3_Amin_G2x_2 PL_C3_Amin_G2x_3 PL_C3_Amin_G2x_4 PL_C3_Amin_G2x_5 BL_C1_Amin BL_C1_A2x BL_C2_Amin BL_C3_Amin WL_C1_Amin WL_C1_A2x WL_C2_Amin WL_C3_Amin VBW_C3
* Group C1-Amin: shared BL_C1_Amin / WL_C1_Amin, private PL per instance, bodies to VSS_ANALOG.
Xinst_C1_Amin_Gmin_1 BL_C1_Amin WL_C1_Amin PL_C1_Amin_Gmin_1 VSS_ANALOG cell_candidate1
Xinst_C1_Amin_Gmin_2 BL_C1_Amin WL_C1_Amin PL_C1_Amin_Gmin_2 VSS_ANALOG cell_candidate1
Xinst_C1_Amin_Gmin_3 BL_C1_Amin WL_C1_Amin PL_C1_Amin_Gmin_3 VSS_ANALOG cell_candidate1
Xinst_C1_Amin_Gmin_4 BL_C1_Amin WL_C1_Amin PL_C1_Amin_Gmin_4 VSS_ANALOG cell_candidate1
Xinst_C1_Amin_G2x_1 BL_C1_Amin WL_C1_Amin PL_C1_Amin_G2x_1 VSS_ANALOG cell_candidate1_Amin_G2x
Xinst_C1_Amin_G2x_2 BL_C1_Amin WL_C1_Amin PL_C1_Amin_G2x_2 VSS_ANALOG cell_candidate1_Amin_G2x
Xinst_C1_Amin_G2x_3 BL_C1_Amin WL_C1_Amin PL_C1_Amin_G2x_3 VSS_ANALOG cell_candidate1_Amin_G2x
Xinst_C1_Amin_G2x_4 BL_C1_Amin WL_C1_Amin PL_C1_Amin_G2x_4 VSS_ANALOG cell_candidate1_Amin_G2x
* Group C1-A2x: shared BL_C1_A2x / WL_C1_A2x, private PL per instance, bodies to VSS_ANALOG.
Xinst_C1_A2x_Gmin_1 BL_C1_A2x WL_C1_A2x PL_C1_A2x_Gmin_1 VSS_ANALOG cell_candidate1_A2x_Gmin
Xinst_C1_A2x_Gmin_2 BL_C1_A2x WL_C1_A2x PL_C1_A2x_Gmin_2 VSS_ANALOG cell_candidate1_A2x_Gmin
Xinst_C1_A2x_Gmin_3 BL_C1_A2x WL_C1_A2x PL_C1_A2x_Gmin_3 VSS_ANALOG cell_candidate1_A2x_Gmin
Xinst_C1_A2x_Gmin_4 BL_C1_A2x WL_C1_A2x PL_C1_A2x_Gmin_4 VSS_ANALOG cell_candidate1_A2x_Gmin
Xinst_C1_A2x_G2x_1 BL_C1_A2x WL_C1_A2x PL_C1_A2x_G2x_1 VSS_ANALOG cell_candidate1_A2x_G2x
Xinst_C1_A2x_G2x_2 BL_C1_A2x WL_C1_A2x PL_C1_A2x_G2x_2 VSS_ANALOG cell_candidate1_A2x_G2x
Xinst_C1_A2x_G2x_3 BL_C1_A2x WL_C1_A2x PL_C1_A2x_G2x_3 VSS_ANALOG cell_candidate1_A2x_G2x
Xinst_C1_A2x_G2x_4 BL_C1_A2x WL_C1_A2x PL_C1_A2x_G2x_4 VSS_ANALOG cell_candidate1_A2x_G2x
* Group C2-Amin: shared BL_C2_Amin / WL_C2_Amin, private PL per instance, bodies to VSS_ANALOG.
Xinst_C2_Amin_Gmin_1 BL_C2_Amin WL_C2_Amin PL_C2_Amin_Gmin_1 VSS_ANALOG cell_candidate2
Xinst_C2_Amin_Gmin_2 BL_C2_Amin WL_C2_Amin PL_C2_Amin_Gmin_2 VSS_ANALOG cell_candidate2
Xinst_C2_Amin_Gmin_3 BL_C2_Amin WL_C2_Amin PL_C2_Amin_Gmin_3 VSS_ANALOG cell_candidate2
Xinst_C2_Amin_Gmin_4 BL_C2_Amin WL_C2_Amin PL_C2_Amin_Gmin_4 VSS_ANALOG cell_candidate2
Xinst_C2_Amin_Gmin_5 BL_C2_Amin WL_C2_Amin PL_C2_Amin_Gmin_5 VSS_ANALOG cell_candidate2
* Group C3-Amin: shared BL_C3_Amin / WL_C3_Amin, private PL per instance, bodies to VBW_C3.
Xinst_C3_Amin_Gmin_1 BL_C3_Amin WL_C3_Amin PL_C3_Amin_Gmin_1 VBW_C3 cell_candidate3
Xinst_C3_Amin_Gmin_2 BL_C3_Amin WL_C3_Amin PL_C3_Amin_Gmin_2 VBW_C3 cell_candidate3
Xinst_C3_Amin_Gmin_3 BL_C3_Amin WL_C3_Amin PL_C3_Amin_Gmin_3 VBW_C3 cell_candidate3
Xinst_C3_Amin_Gmin_4 BL_C3_Amin WL_C3_Amin PL_C3_Amin_Gmin_4 VBW_C3 cell_candidate3
Xinst_C3_Amin_Gmin_5 BL_C3_Amin WL_C3_Amin PL_C3_Amin_Gmin_5 VBW_C3 cell_candidate3
Xinst_C3_Amin_G2x_1 BL_C3_Amin WL_C3_Amin PL_C3_Amin_G2x_1 VBW_C3 cell_candidate3_Amin_G2x
Xinst_C3_Amin_G2x_2 BL_C3_Amin WL_C3_Amin PL_C3_Amin_G2x_2 VBW_C3 cell_candidate3_Amin_G2x
Xinst_C3_Amin_G2x_3 BL_C3_Amin WL_C3_Amin PL_C3_Amin_G2x_3 VBW_C3 cell_candidate3_Amin_G2x
Xinst_C3_Amin_G2x_4 BL_C3_Amin WL_C3_Amin PL_C3_Amin_G2x_4 VBW_C3 cell_candidate3_Amin_G2x
Xinst_C3_Amin_G2x_5 BL_C3_Amin WL_C3_Amin PL_C3_Amin_G2x_5 VBW_C3 cell_candidate3_Amin_G2x
.ends
