* run3_top -- chip-level reference netlist for the run3 test chip
* (issue #275, part of #203).
* Generated by layout/run3_top/generate_run3_top.py -- DO NOT EDIT.
* Regenerate and verify: python3 -I layout/run3_top/generate_run3_top.py --check
*
* Geometry basis (README.md states it in exactly one place): capacitor
* W/L at the ratified levels of spec/capacitor-geometry-decision.md;
* access W/L at the drawn XM1 literals of layout/cell_*/lvs_reference.spice.
* The capacitor half knowingly disagrees with all seven committed cells
* until #296 lands; design/check-geometry-basis.py owns that divergence
* record, scripts/check_run3_pad_table.py re-checks each half against its
* binding source.
*
* cell_candidate2_Amin_G2x has no drawn cell (#296; #299 rules on drawing
* the Candidate 2 G2x cell at all): access literals from cell_candidate2
* (same Amin level), capacitor from the ratified record.
*
* The substrate net VSS_ANALOG is the generator's placeholder for the
* C1/C2 p-substrate tie; it is NOT a ratified name
* (spec/supply-domains-decision.md rows 2/13/14, OI-2/OI-6). C3's n-well
* tie is the VBW_C3 pad net.
*
* Written to the klt lvs reference.form = "subckt-call" shape
* (top = "run3_top"); whether klt resolves this hierarchical form is
* first exercised at chip assembly (#211). It is not asserted here that
* the netlist passes klt lvs.

* ---- per-geometry cell subcircuits (8 points) ----

.subckt cell_candidate1 BL WL PL VB
* access: drawn XM1 literal (layout/cell_candidate1/lvs_reference.spice)
XM1 BL WL CN VB nfet_06v0 L=0.70u W=0.42u nf=1 m=1
* capacitor: ratified Gmin level (spec/capacitor-geometry-decision.md)
XC1 CN PL cap_nmos_03v3 c_width=1.0u c_length=0.28u m=1
.ends

.subckt cell_candidate1_Amin_G2x BL WL PL VB
* access: drawn XM1 literal (layout/cell_candidate1_Amin_G2x/lvs_reference.spice)
XM1 BL WL CN VB nfet_06v0 L=0.70u W=0.42u nf=1 m=1
* capacitor: ratified G2x level (spec/capacitor-geometry-decision.md)
XC1 CN PL cap_nmos_03v3 c_width=2.0u c_length=0.28u m=1
.ends

.subckt cell_candidate1_A2x_Gmin BL WL PL VB
* access: drawn XM1 literal (layout/cell_candidate1_A2x_Gmin/lvs_reference.spice)
XM1 BL WL CN VB nfet_06v0 L=0.70u W=0.84u nf=1 m=1
* capacitor: ratified Gmin level (spec/capacitor-geometry-decision.md)
XC1 CN PL cap_nmos_03v3 c_width=1.0u c_length=0.28u m=1
.ends

.subckt cell_candidate1_A2x_G2x BL WL PL VB
* access: drawn XM1 literal (layout/cell_candidate1_A2x_G2x/lvs_reference.spice)
XM1 BL WL CN VB nfet_06v0 L=0.70u W=0.84u nf=1 m=1
* capacitor: ratified G2x level (spec/capacitor-geometry-decision.md)
XC1 CN PL cap_nmos_03v3 c_width=2.0u c_length=0.28u m=1
.ends

.subckt cell_candidate2 BL WL PL VB
* access: drawn XM1 literal (layout/cell_candidate2/lvs_reference.spice)
XM1 BL WL CN VB nfet_10v0_asym L=0.60u W=8u nf=2 m=1
* capacitor: ratified Gmin level (spec/capacitor-geometry-decision.md)
XC1 CN PL cap_nmos_06v0 c_width=1.0u c_length=0.70u m=1
.ends

.subckt cell_candidate2_Amin_G2x BL WL PL VB
* access: drawn XM1 literal (layout/cell_candidate2_Amin_G2x/lvs_reference.spice)
* NO DRAWN CELL (#296; #299 rules on drawing the Candidate 2 G2x cell):
* access literals from cell_candidate2 (same Amin level), capacitor
* from the ratified record. Its absence blocks #211's LVS, not this issue.
XM1 BL WL CN VB nfet_10v0_asym L=0.60u W=8u nf=2 m=1
* capacitor: ratified G2x level (spec/capacitor-geometry-decision.md)
XC1 CN PL cap_nmos_06v0 c_width=2.0u c_length=0.70u m=1
.ends

.subckt cell_candidate3 BL WL PL VB
* access: drawn XM1 literal (layout/cell_candidate3/lvs_reference.spice)
XM1 CN WL BL VB pfet_06v0 L=0.55u W=0.42u nf=1 m=1
* capacitor: ratified Gmin level (spec/capacitor-geometry-decision.md)
XC1 CN PL cap_pmos_03v3 c_width=1.0u c_length=0.28u m=1
.ends

.subckt cell_candidate3_Amin_G2x BL WL PL VB
* access: drawn XM1 literal (layout/cell_candidate3_Amin_G2x/lvs_reference.spice)
XM1 CN WL BL VB pfet_06v0 L=0.55u W=0.42u nf=1 m=1
* capacitor: ratified G2x level (spec/capacitor-geometry-decision.md)
XC1 CN PL cap_pmos_03v3 c_width=2.0u c_length=0.28u m=1
.ends

* ---- top: 36 instances, 45 signal ports ----

.subckt run3_top PL_C1_Amin_Gmin_1 PL_C1_Amin_Gmin_2 PL_C1_Amin_Gmin_3 PL_C1_Amin_Gmin_4 PL_C1_Amin_G2x_1 PL_C1_Amin_G2x_2 PL_C1_Amin_G2x_3 PL_C1_Amin_G2x_4 PL_C1_A2x_Gmin_1 PL_C1_A2x_Gmin_2 PL_C1_A2x_Gmin_3 PL_C1_A2x_Gmin_4 PL_C1_A2x_G2x_1 PL_C1_A2x_G2x_2 PL_C1_A2x_G2x_3 PL_C1_A2x_G2x_4 PL_C2_Amin_Gmin_1 PL_C2_Amin_Gmin_2 PL_C2_Amin_Gmin_3 PL_C2_Amin_Gmin_4 PL_C2_Amin_Gmin_5 PL_C2_Amin_G2x_1 PL_C2_Amin_G2x_2 PL_C2_Amin_G2x_3 PL_C2_Amin_G2x_4 PL_C2_Amin_G2x_5 PL_C3_Amin_Gmin_1 PL_C3_Amin_Gmin_2 PL_C3_Amin_Gmin_3 PL_C3_Amin_Gmin_4 PL_C3_Amin_Gmin_5 PL_C3_Amin_G2x_1 PL_C3_Amin_G2x_2 PL_C3_Amin_G2x_3 PL_C3_Amin_G2x_4 PL_C3_Amin_G2x_5 BL_C1_Amin BL_C1_A2x BL_C2_Amin BL_C3_Amin WL_C1_Amin WL_C1_A2x WL_C2_Amin WL_C3_Amin VBW_C3
* Group C1-Amin: shared BL_C1_Amin / WL_C1_Amin, private PL per instance, bodies to VSS_ANALOG.
Xinst_C1_Amin_Gmin_1 BL_C1_Amin WL_C1_Amin PL_C1_Amin_Gmin_1 VSS_ANALOG cell_candidate1
Xinst_C1_Amin_Gmin_2 BL_C1_Amin WL_C1_Amin PL_C1_Amin_Gmin_2 VSS_ANALOG cell_candidate1
Xinst_C1_Amin_Gmin_3 BL_C1_Amin WL_C1_Amin PL_C1_Amin_Gmin_3 VSS_ANALOG cell_candidate1
Xinst_C1_Amin_Gmin_4 BL_C1_Amin WL_C1_Amin PL_C1_Amin_Gmin_4 VSS_ANALOG cell_candidate1
Xinst_C1_Amin_G2x_1 BL_C1_Amin WL_C1_Amin PL_C1_Amin_G2x_1 VSS_ANALOG cell_candidate1_Amin_G2x
Xinst_C1_Amin_G2x_2 BL_C1_Amin WL_C1_Amin PL_C1_Amin_G2x_2 VSS_ANALOG cell_candidate1_Amin_G2x
Xinst_C1_Amin_G2x_3 BL_C1_Amin WL_C1_Amin PL_C1_Amin_G2x_3 VSS_ANALOG cell_candidate1_Amin_G2x
Xinst_C1_Amin_G2x_4 BL_C1_Amin WL_C1_Amin PL_C1_Amin_G2x_4 VSS_ANALOG cell_candidate1_Amin_G2x
* Group C1-A2x: shared BL_C1_A2x / WL_C1_A2x, private PL per instance, bodies to VSS_ANALOG.
Xinst_C1_A2x_Gmin_1 BL_C1_A2x WL_C1_A2x PL_C1_A2x_Gmin_1 VSS_ANALOG cell_candidate1_A2x_Gmin
Xinst_C1_A2x_Gmin_2 BL_C1_A2x WL_C1_A2x PL_C1_A2x_Gmin_2 VSS_ANALOG cell_candidate1_A2x_Gmin
Xinst_C1_A2x_Gmin_3 BL_C1_A2x WL_C1_A2x PL_C1_A2x_Gmin_3 VSS_ANALOG cell_candidate1_A2x_Gmin
Xinst_C1_A2x_Gmin_4 BL_C1_A2x WL_C1_A2x PL_C1_A2x_Gmin_4 VSS_ANALOG cell_candidate1_A2x_Gmin
Xinst_C1_A2x_G2x_1 BL_C1_A2x WL_C1_A2x PL_C1_A2x_G2x_1 VSS_ANALOG cell_candidate1_A2x_G2x
Xinst_C1_A2x_G2x_2 BL_C1_A2x WL_C1_A2x PL_C1_A2x_G2x_2 VSS_ANALOG cell_candidate1_A2x_G2x
Xinst_C1_A2x_G2x_3 BL_C1_A2x WL_C1_A2x PL_C1_A2x_G2x_3 VSS_ANALOG cell_candidate1_A2x_G2x
Xinst_C1_A2x_G2x_4 BL_C1_A2x WL_C1_A2x PL_C1_A2x_G2x_4 VSS_ANALOG cell_candidate1_A2x_G2x
* Group C2-Amin: shared BL_C2_Amin / WL_C2_Amin, private PL per instance, bodies to VSS_ANALOG.
Xinst_C2_Amin_Gmin_1 BL_C2_Amin WL_C2_Amin PL_C2_Amin_Gmin_1 VSS_ANALOG cell_candidate2
Xinst_C2_Amin_Gmin_2 BL_C2_Amin WL_C2_Amin PL_C2_Amin_Gmin_2 VSS_ANALOG cell_candidate2
Xinst_C2_Amin_Gmin_3 BL_C2_Amin WL_C2_Amin PL_C2_Amin_Gmin_3 VSS_ANALOG cell_candidate2
Xinst_C2_Amin_Gmin_4 BL_C2_Amin WL_C2_Amin PL_C2_Amin_Gmin_4 VSS_ANALOG cell_candidate2
Xinst_C2_Amin_Gmin_5 BL_C2_Amin WL_C2_Amin PL_C2_Amin_Gmin_5 VSS_ANALOG cell_candidate2
Xinst_C2_Amin_G2x_1 BL_C2_Amin WL_C2_Amin PL_C2_Amin_G2x_1 VSS_ANALOG cell_candidate2_Amin_G2x
Xinst_C2_Amin_G2x_2 BL_C2_Amin WL_C2_Amin PL_C2_Amin_G2x_2 VSS_ANALOG cell_candidate2_Amin_G2x
Xinst_C2_Amin_G2x_3 BL_C2_Amin WL_C2_Amin PL_C2_Amin_G2x_3 VSS_ANALOG cell_candidate2_Amin_G2x
Xinst_C2_Amin_G2x_4 BL_C2_Amin WL_C2_Amin PL_C2_Amin_G2x_4 VSS_ANALOG cell_candidate2_Amin_G2x
Xinst_C2_Amin_G2x_5 BL_C2_Amin WL_C2_Amin PL_C2_Amin_G2x_5 VSS_ANALOG cell_candidate2_Amin_G2x
* Group C3-Amin: shared BL_C3_Amin / WL_C3_Amin, private PL per instance, bodies to VBW_C3.
Xinst_C3_Amin_Gmin_1 BL_C3_Amin WL_C3_Amin PL_C3_Amin_Gmin_1 VBW_C3 cell_candidate3
Xinst_C3_Amin_Gmin_2 BL_C3_Amin WL_C3_Amin PL_C3_Amin_Gmin_2 VBW_C3 cell_candidate3
Xinst_C3_Amin_Gmin_3 BL_C3_Amin WL_C3_Amin PL_C3_Amin_Gmin_3 VBW_C3 cell_candidate3
Xinst_C3_Amin_Gmin_4 BL_C3_Amin WL_C3_Amin PL_C3_Amin_Gmin_4 VBW_C3 cell_candidate3
Xinst_C3_Amin_Gmin_5 BL_C3_Amin WL_C3_Amin PL_C3_Amin_Gmin_5 VBW_C3 cell_candidate3
Xinst_C3_Amin_G2x_1 BL_C3_Amin WL_C3_Amin PL_C3_Amin_G2x_1 VBW_C3 cell_candidate3_Amin_G2x
Xinst_C3_Amin_G2x_2 BL_C3_Amin WL_C3_Amin PL_C3_Amin_G2x_2 VBW_C3 cell_candidate3_Amin_G2x
Xinst_C3_Amin_G2x_3 BL_C3_Amin WL_C3_Amin PL_C3_Amin_G2x_3 VBW_C3 cell_candidate3_Amin_G2x
Xinst_C3_Amin_G2x_4 BL_C3_Amin WL_C3_Amin PL_C3_Amin_G2x_4 VBW_C3 cell_candidate3_Amin_G2x
Xinst_C3_Amin_G2x_5 BL_C3_Amin WL_C3_Amin PL_C3_Amin_G2x_5 VBW_C3 cell_candidate3_Amin_G2x
.ends
