.subckt pg_n06 A G B VB
XM1 A G B VB nfet_06v0 L=0.7u W=20u nf=1 m=1
.ends
