* GF180D native LVS extraction, combined parallel devices.

.SUBCKT ls_hv10 IN OUT OUTB VDDH VDDL VSS
M$1 \$3 IN VDDL VDDL pfet_03v3 L=0.28U W=4U AS=2P AD=2P PS=9U PD=9U
M$2 OUT OUTB VDDH VDDH pfet_10v0_asym L=0.6U W=8U AS=5.24P AD=5.24P PS=14.62U
+ PD=14.62U
M$4 OUTB OUT VDDH VDDH pfet_10v0_asym L=0.6U W=8U AS=5.24P AD=5.24P PS=14.62U
+ PD=14.62U
M$6 \$3 IN VSS VSS nfet_03v3 L=0.28U W=2U AS=1P AD=1P PS=5U PD=5U
M$7 OUTB IN VSS VSS nfet_10v0_asym L=0.6U W=20U AS=13.1P AD=13.1P PS=32.62U
+ PD=32.62U
M$9 OUT \$3 VSS VSS nfet_10v0_asym L=0.6U W=20U AS=13.1P AD=13.1P PS=32.62U
+ PD=32.62U
.ENDS ls_hv10
