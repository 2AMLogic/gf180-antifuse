* LVS reference for layout/cell_candidate3/cell_candidate3.gds.
* Derived from design/netlists/cell_candidate3.spice (do not edit that file):
* same subcircuit, same device models and connectivity, with the subcircuit's
* parameters (wcap, lcap, wacc, lacc) resolved to the drawn Minimum x Minimum
* geometry point, because klt lvs --reference-form subckt-call cannot carry
* parameter expressions. Only literal geometry differs from the source netlist.
.subckt cell_candidate3 BL WL PL VB
XM1 CN WL BL VB pfet_06v0 L=0.55u W=0.42u nf=1 m=1
XC1 CN PL cap_pmos_03v3 c_width=0.42u c_length=0.28u m=1
.ends
