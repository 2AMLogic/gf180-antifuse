* gf180-antifuse sim/integrated-transition: slice_ii_iii, process corner typical (GENERATED by make_bench.py - do not edit)
* Circuit body for `klt sim`. The MOS and moscap sections come from the request's corner bundle;
* design.ngspice (global switches) and the 10 V LDMOS library's matching section are resolved from
* $PDK_ROOT on whichever host runs the corner. See README.md for the sequence and the assumptions.
.include $PDK_ROOT/gf180mcuD/libs.tech/ngspice/design.ngspice
.lib "$PDK_ROOT/gf180mcuD/libs.tech/ngspice/smbb000149.ngspice" typical
* derived netlists of the design under test (design/netlists/, never copied)
.include ../../../design/netlists/cell_candidate1.spice
.include ../../../design/netlists/cell_candidate2.spice
.include ../../../design/netlists/cell_candidate3.spice
.include ../../../design/netlists/ls_hv06.spice
.include ../../../design/netlists/ls_hv10.spice
.include ../../../design/netlists/pg_n06.spice
.include ../../../design/netlists/pg_n10.spice
.include ../../../design/netlists/leg_interlock.spice
.include ../../../design/netlists/program_leg.spice
.include ../../../design/netlists/read_leg.spice
.include ../../../design/netlists/slice_ii_iii.spice

X_dut RSEL_0 RSEL_1 RSEL_2 RSEL_3 CSEL_20 CSEL_21 CSEL_22 CSEL_23 BLG_II PLG_II BLG_III PLG_III VDDH_II VDDH_III vdd 0 slice_ii_iii

* ---- supplies. Sweep keys are the V* elements (element name == klt supply_v key) and hold the
* final level; each rail reaches it through a C-infinity power-up ramp (B element), because under
* `uic` every node starts at 0 V and a step would be an unphysical power-up. Nothing is measured
* before 0.5 us. VPP and the bit-line buses are NOT ramped separately: VPP follows VDD up, then
* ramps to Vpk as a scenario event.
Vdd vddk 0 DC 3.3
Vclamp vclampk 0 DC 1.8
Vpk vpk 0 DC 5.0
Bdd vdd 0 V='v(vddk)*af_edge((time+20n)/0.25u)'
Bclamp vclamp 0 V='v(vclampk)*af_edge((time+20n)/0.25u)'
Vddh_II VDDHK_II 0 DC 5.5
Bddh_II VDDH_II 0 V='v(VDDHK_II)*af_edge((time+20n)/0.25u)'
Vplg_II PLG_II 0 DC 0
Vddh_III VDDHK_III 0 DC 5.0
Bddh_III VDDH_III 0 V='v(VDDHK_III)*af_edge((time+20n)/0.25u)'
Vplg_III PLG_III 0 DC 0

* ---- scenario keys: times in microseconds (value in 'volts'), enables are 0/1 ----
Vtvr tvr 0 DC 0.02
Vtcsl tcsl 0 DC 0.0
Vtpe tpe 0 DC 1.8
Vtpf tpf 0 DC 2.8
Vtren tren 0 DC 2.8
Vtdis tdis 0 DC 99.0
Ven_r0 en_r0 0 DC 0
Ven_r1 en_r1 0 DC 0
Ven_r2 en_r2 0 DC 0
Ven_r3 en_r3 0 DC 0
Ven_c20 en_c20 0 DC 0
Ven_c21 en_c21 0 DC 0
Ven_c22 en_c22 0 DC 0
Ven_c23 en_c23 0 DC 0
Vbsel_II bsel_II 0 DC 0
Vbsel_III bsel_III 0 DC 0
Vgfil gfil 0 DC 0

* ---- control waveforms (behavioural; logic highs track VDD like the legs bench) ----
* C-infinity edge f(u)/(f(u)+f(1-u)), f(u)=exp(-1/u): the stock moscap macro stalls on slope
* discontinuities (sim/cell-breakdown-model/README.md, 'Transient convergence (#74)')
.func af_fe(u) {exp(-1/max(u,1e-6))}
.func af_edge(x) {af_fe(min(max(x,0),1))/(af_fe(min(max(x,0),1))+af_fe(1-min(max(x,0),1)))}
* external VPP: idle at VDD, ramps to Vpk starting 0.6 us over tvr (>= 20 ns)
Bvpp vpp 0 V='v(vdd)+(v(vpk)-v(vdd))*af_edge((time-0.6u)/max(v(tvr)*1u,20n))'
Brsel0 RSEL_0 0 V='v(vdd)*v(en_r0)*(af_edge((time-1.2u)/1e-07)-af_edge((time-v(tdis)*1u)/1e-07))'
Brsel1 RSEL_1 0 V='v(vdd)*v(en_r1)*(af_edge((time-1.2u)/1e-07)-af_edge((time-v(tdis)*1u)/1e-07))'
Brsel2 RSEL_2 0 V='v(vdd)*v(en_r2)*(af_edge((time-1.2u)/1e-07)-af_edge((time-v(tdis)*1u)/1e-07))'
Brsel3 RSEL_3 0 V='v(vdd)*v(en_r3)*(af_edge((time-1.2u)/1e-07)-af_edge((time-v(tdis)*1u)/1e-07))'
Bcsel20 CSEL_20 0 V='v(vdd)*v(en_c20)*(af_edge((time-1.2u-v(tcsl)*1u)/1e-07)-af_edge((time-v(tdis)*1u)/1e-07))'
Bcsel21 CSEL_21 0 V='v(vdd)*v(en_c21)*(af_edge((time-1.2u-v(tcsl)*1u)/1e-07)-af_edge((time-v(tdis)*1u)/1e-07))'
Bcsel22 CSEL_22 0 V='v(vdd)*v(en_c22)*(af_edge((time-1.2u-v(tcsl)*1u)/1e-07)-af_edge((time-v(tdis)*1u)/1e-07))'
Bcsel23 CSEL_23 0 V='v(vdd)*v(en_c23)*(af_edge((time-1.2u-v(tcsl)*1u)/1e-07)-af_edge((time-v(tdis)*1u)/1e-07))'
Bpen_ii pen_ii 0 V='v(vdd)*v(bsel_II)*(af_edge((time-v(tpe)*1u)/1e-07)-af_edge((time-v(tpf)*1u)/1e-07))'
Bren_ii ren_ii 0 V='v(vdd)*v(bsel_II)*af_edge((time-v(tren)*1u)/1e-07)'
Bpen_iii pen_iii 0 V='v(vdd)*v(bsel_III)*(af_edge((time-v(tpe)*1u)/1e-07)-af_edge((time-v(tpf)*1u)/1e-07))'
Bren_iii ren_iii 0 V='v(vdd)*v(bsel_III)*af_edge((time-v(tren)*1u)/1e-07)'

* ---- legs on each band's global bit-line bus; ammeters read the leg currents ----
* i(vamp_<b>) > 0: program leg drives the bus.  i(vamr_<b>) < 0: bus sinks into the read leg.
Vamp_ii blp_ii BLG_II DC 0
Vamr_ii blr_ii BLG_II DC 0
Xpg_ii pen_ii ren_ii vdd 0 blp_ii vpp program_leg
Xrd_ii pen_ii ren_ii vclamp iref_ii vdd 0 blr_ii sense_ii rdata_ii read_leg
Iref_ii 0 iref_ii DC 1e-06
Rbleed_ii BLG_II 0 1e+10
* both-legs-on detector: min(PON, RON) (volts); 0 means never both ON
Bboth_ii both_ii 0 V='min(v(xpg_ii.pon),v(xrd_ii.ron))'
Vamp_iii blp_iii BLG_III DC 0
Vamr_iii blr_iii BLG_III DC 0
Xpg_iii pen_iii ren_iii vdd 0 blp_iii vpp program_leg
Xrd_iii pen_iii ren_iii vclamp iref_iii vdd 0 blr_iii sense_iii rdata_iii read_leg
Iref_iii 0 iref_iii DC 1e-06
Rbleed_iii BLG_III 0 1e+10
* both-legs-on detector: min(PON, RON) (volts); 0 means never both ON
Bboth_iii both_iii 0 V='min(v(xpg_iii.pon),v(xrd_iii.ron))'

* ---- assumed programmed-cell filament across the SELECTED cell's capacitor only ----
* (conductance = v(gfil); 0 = unprogrammed). Not a breakdown model.
Bfil_0_20 x_dut.xc_0_20.cn x_dut.pl_0_II I='v(x_dut.xc_0_20.cn,x_dut.pl_0_II)*v(gfil)*v(en_r0)*v(en_c20)'
Bfil_0_21 x_dut.xc_0_21.cn x_dut.pl_0_II I='v(x_dut.xc_0_21.cn,x_dut.pl_0_II)*v(gfil)*v(en_r0)*v(en_c21)'
Bfil_0_22 x_dut.xc_0_22.cn x_dut.pl_0_III I='v(x_dut.xc_0_22.cn,x_dut.pl_0_III)*v(gfil)*v(en_r0)*v(en_c22)'
Bfil_0_23 x_dut.xc_0_23.cn x_dut.pl_0_III I='v(x_dut.xc_0_23.cn,x_dut.pl_0_III)*v(gfil)*v(en_r0)*v(en_c23)'
Bfil_1_20 x_dut.xc_1_20.cn x_dut.pl_1_II I='v(x_dut.xc_1_20.cn,x_dut.pl_1_II)*v(gfil)*v(en_r1)*v(en_c20)'
Bfil_1_21 x_dut.xc_1_21.cn x_dut.pl_1_II I='v(x_dut.xc_1_21.cn,x_dut.pl_1_II)*v(gfil)*v(en_r1)*v(en_c21)'
Bfil_1_22 x_dut.xc_1_22.cn x_dut.pl_1_III I='v(x_dut.xc_1_22.cn,x_dut.pl_1_III)*v(gfil)*v(en_r1)*v(en_c22)'
Bfil_1_23 x_dut.xc_1_23.cn x_dut.pl_1_III I='v(x_dut.xc_1_23.cn,x_dut.pl_1_III)*v(gfil)*v(en_r1)*v(en_c23)'
Bfil_2_20 x_dut.xc_2_20.cn x_dut.pl_2_II I='v(x_dut.xc_2_20.cn,x_dut.pl_2_II)*v(gfil)*v(en_r2)*v(en_c20)'
Bfil_2_21 x_dut.xc_2_21.cn x_dut.pl_2_II I='v(x_dut.xc_2_21.cn,x_dut.pl_2_II)*v(gfil)*v(en_r2)*v(en_c21)'
Bfil_2_22 x_dut.xc_2_22.cn x_dut.pl_2_III I='v(x_dut.xc_2_22.cn,x_dut.pl_2_III)*v(gfil)*v(en_r2)*v(en_c22)'
Bfil_2_23 x_dut.xc_2_23.cn x_dut.pl_2_III I='v(x_dut.xc_2_23.cn,x_dut.pl_2_III)*v(gfil)*v(en_r2)*v(en_c23)'
Bfil_3_20 x_dut.xc_3_20.cn x_dut.pl_3_II I='v(x_dut.xc_3_20.cn,x_dut.pl_3_II)*v(gfil)*v(en_r3)*v(en_c20)'
Bfil_3_21 x_dut.xc_3_21.cn x_dut.pl_3_II I='v(x_dut.xc_3_21.cn,x_dut.pl_3_II)*v(gfil)*v(en_r3)*v(en_c21)'
Bfil_3_22 x_dut.xc_3_22.cn x_dut.pl_3_III I='v(x_dut.xc_3_22.cn,x_dut.pl_3_III)*v(gfil)*v(en_r3)*v(en_c22)'
Bfil_3_23 x_dut.xc_3_23.cn x_dut.pl_3_III I='v(x_dut.xc_3_23.cn,x_dut.pl_3_III)*v(gfil)*v(en_r3)*v(en_c23)'

* ---- stress probes: |V(a)-V(b)| of every terminal pair of every HV-exposed device ----
* (ngspice allows at most 99 par() calls and no v(a,b) in .meas, so each pair is a B source)
Bsp_st0gs sp_st0gs 0 V='abs(v(x_dut.wl_0_ii)-v(x_dut.xc_0_20.cn))'
Bsp_st0gd sp_st0gd 0 V='abs(v(x_dut.wl_0_ii)-v(x_dut.bl_20))'
Bsp_st0ds sp_st0ds 0 V='abs(v(x_dut.bl_20)-v(x_dut.xc_0_20.cn))'
Bsp_st1t12 sp_st1t12 0 V='abs(v(x_dut.xc_0_20.cn)-v(x_dut.pl_0_ii))'
Bsp_st2gs sp_st2gs 0 V='abs(v(x_dut.wl_0_ii)-v(x_dut.xc_0_21.cn))'
Bsp_st2gd sp_st2gd 0 V='abs(v(x_dut.wl_0_ii)-v(x_dut.bl_21))'
Bsp_st2ds sp_st2ds 0 V='abs(v(x_dut.bl_21)-v(x_dut.xc_0_21.cn))'
Bsp_st3t12 sp_st3t12 0 V='abs(v(x_dut.xc_0_21.cn)-v(x_dut.pl_0_ii))'
Bsp_st4gs sp_st4gs 0 V='abs(v(x_dut.wl_0_iii)-v(x_dut.bl_22))'
Bsp_st4gd sp_st4gd 0 V='abs(v(x_dut.wl_0_iii)-v(x_dut.xc_0_22.cn))'
Bsp_st4ds sp_st4ds 0 V='abs(v(x_dut.xc_0_22.cn)-v(x_dut.bl_22))'
Bsp_st5t12 sp_st5t12 0 V='abs(v(x_dut.xc_0_22.cn)-v(x_dut.pl_0_iii))'
Bsp_st6gs sp_st6gs 0 V='abs(v(x_dut.wl_0_iii)-v(x_dut.bl_23))'
Bsp_st6gd sp_st6gd 0 V='abs(v(x_dut.wl_0_iii)-v(x_dut.xc_0_23.cn))'
Bsp_st6ds sp_st6ds 0 V='abs(v(x_dut.xc_0_23.cn)-v(x_dut.bl_23))'
Bsp_st7t12 sp_st7t12 0 V='abs(v(x_dut.xc_0_23.cn)-v(x_dut.pl_0_iii))'
Bsp_st8gs sp_st8gs 0 V='abs(v(x_dut.wl_1_ii)-v(x_dut.xc_1_20.cn))'
Bsp_st8gd sp_st8gd 0 V='abs(v(x_dut.wl_1_ii)-v(x_dut.bl_20))'
Bsp_st8ds sp_st8ds 0 V='abs(v(x_dut.bl_20)-v(x_dut.xc_1_20.cn))'
Bsp_st9t12 sp_st9t12 0 V='abs(v(x_dut.xc_1_20.cn)-v(x_dut.pl_1_ii))'
Bsp_st10gs sp_st10gs 0 V='abs(v(x_dut.wl_1_ii)-v(x_dut.xc_1_21.cn))'
Bsp_st10gd sp_st10gd 0 V='abs(v(x_dut.wl_1_ii)-v(x_dut.bl_21))'
Bsp_st10ds sp_st10ds 0 V='abs(v(x_dut.bl_21)-v(x_dut.xc_1_21.cn))'
Bsp_st11t12 sp_st11t12 0 V='abs(v(x_dut.xc_1_21.cn)-v(x_dut.pl_1_ii))'
Bsp_st12gs sp_st12gs 0 V='abs(v(x_dut.wl_1_iii)-v(x_dut.bl_22))'
Bsp_st12gd sp_st12gd 0 V='abs(v(x_dut.wl_1_iii)-v(x_dut.xc_1_22.cn))'
Bsp_st12ds sp_st12ds 0 V='abs(v(x_dut.xc_1_22.cn)-v(x_dut.bl_22))'
Bsp_st13t12 sp_st13t12 0 V='abs(v(x_dut.xc_1_22.cn)-v(x_dut.pl_1_iii))'
Bsp_st14gs sp_st14gs 0 V='abs(v(x_dut.wl_1_iii)-v(x_dut.bl_23))'
Bsp_st14gd sp_st14gd 0 V='abs(v(x_dut.wl_1_iii)-v(x_dut.xc_1_23.cn))'
Bsp_st14ds sp_st14ds 0 V='abs(v(x_dut.xc_1_23.cn)-v(x_dut.bl_23))'
Bsp_st15t12 sp_st15t12 0 V='abs(v(x_dut.xc_1_23.cn)-v(x_dut.pl_1_iii))'
Bsp_st16gs sp_st16gs 0 V='abs(v(x_dut.wl_2_ii)-v(x_dut.xc_2_20.cn))'
Bsp_st16gd sp_st16gd 0 V='abs(v(x_dut.wl_2_ii)-v(x_dut.bl_20))'
Bsp_st16ds sp_st16ds 0 V='abs(v(x_dut.bl_20)-v(x_dut.xc_2_20.cn))'
Bsp_st17t12 sp_st17t12 0 V='abs(v(x_dut.xc_2_20.cn)-v(x_dut.pl_2_ii))'
Bsp_st18gs sp_st18gs 0 V='abs(v(x_dut.wl_2_ii)-v(x_dut.xc_2_21.cn))'
Bsp_st18gd sp_st18gd 0 V='abs(v(x_dut.wl_2_ii)-v(x_dut.bl_21))'
Bsp_st18ds sp_st18ds 0 V='abs(v(x_dut.bl_21)-v(x_dut.xc_2_21.cn))'
Bsp_st19t12 sp_st19t12 0 V='abs(v(x_dut.xc_2_21.cn)-v(x_dut.pl_2_ii))'
Bsp_st20gs sp_st20gs 0 V='abs(v(x_dut.wl_2_iii)-v(x_dut.bl_22))'
Bsp_st20gd sp_st20gd 0 V='abs(v(x_dut.wl_2_iii)-v(x_dut.xc_2_22.cn))'
Bsp_st20ds sp_st20ds 0 V='abs(v(x_dut.xc_2_22.cn)-v(x_dut.bl_22))'
Bsp_st21t12 sp_st21t12 0 V='abs(v(x_dut.xc_2_22.cn)-v(x_dut.pl_2_iii))'
Bsp_st22gs sp_st22gs 0 V='abs(v(x_dut.wl_2_iii)-v(x_dut.bl_23))'
Bsp_st22gd sp_st22gd 0 V='abs(v(x_dut.wl_2_iii)-v(x_dut.xc_2_23.cn))'
Bsp_st22ds sp_st22ds 0 V='abs(v(x_dut.xc_2_23.cn)-v(x_dut.bl_23))'
Bsp_st23t12 sp_st23t12 0 V='abs(v(x_dut.xc_2_23.cn)-v(x_dut.pl_2_iii))'
Bsp_st24gs sp_st24gs 0 V='abs(v(x_dut.wl_3_ii)-v(x_dut.xc_3_20.cn))'
Bsp_st24gd sp_st24gd 0 V='abs(v(x_dut.wl_3_ii)-v(x_dut.bl_20))'
Bsp_st24ds sp_st24ds 0 V='abs(v(x_dut.bl_20)-v(x_dut.xc_3_20.cn))'
Bsp_st25t12 sp_st25t12 0 V='abs(v(x_dut.xc_3_20.cn)-v(x_dut.pl_3_ii))'
Bsp_st26gs sp_st26gs 0 V='abs(v(x_dut.wl_3_ii)-v(x_dut.xc_3_21.cn))'
Bsp_st26gd sp_st26gd 0 V='abs(v(x_dut.wl_3_ii)-v(x_dut.bl_21))'
Bsp_st26ds sp_st26ds 0 V='abs(v(x_dut.bl_21)-v(x_dut.xc_3_21.cn))'
Bsp_st27t12 sp_st27t12 0 V='abs(v(x_dut.xc_3_21.cn)-v(x_dut.pl_3_ii))'
Bsp_st28gs sp_st28gs 0 V='abs(v(x_dut.wl_3_iii)-v(x_dut.bl_22))'
Bsp_st28gd sp_st28gd 0 V='abs(v(x_dut.wl_3_iii)-v(x_dut.xc_3_22.cn))'
Bsp_st28ds sp_st28ds 0 V='abs(v(x_dut.xc_3_22.cn)-v(x_dut.bl_22))'
Bsp_st29t12 sp_st29t12 0 V='abs(v(x_dut.xc_3_22.cn)-v(x_dut.pl_3_iii))'
Bsp_st30gs sp_st30gs 0 V='abs(v(x_dut.wl_3_iii)-v(x_dut.bl_23))'
Bsp_st30gd sp_st30gd 0 V='abs(v(x_dut.wl_3_iii)-v(x_dut.xc_3_23.cn))'
Bsp_st30ds sp_st30ds 0 V='abs(v(x_dut.xc_3_23.cn)-v(x_dut.bl_23))'
Bsp_st31t12 sp_st31t12 0 V='abs(v(x_dut.xc_3_23.cn)-v(x_dut.pl_3_iii))'
Bsp_st32gs sp_st32gs 0 V='abs(v(csel_20)-v(0))'
Bsp_st32gd sp_st32gd 0 V='abs(v(csel_20)-v(x_dut.cgb_20))'
Bsp_st32ds sp_st32ds 0 V='abs(v(x_dut.cgb_20)-v(0))'
Bsp_st33gs sp_st33gs 0 V='abs(v(x_dut.xlc_20.inb)-v(0))'
Bsp_st33gd sp_st33gd 0 V='abs(v(x_dut.xlc_20.inb)-v(x_dut.cg_20))'
Bsp_st33ds sp_st33ds 0 V='abs(v(x_dut.cg_20)-v(0))'
Bsp_st34gs sp_st34gs 0 V='abs(v(x_dut.cgb_20)-v(vddh_ii))'
Bsp_st34gd sp_st34gd 0 V='abs(v(x_dut.cgb_20)-v(x_dut.cg_20))'
Bsp_st34ds sp_st34ds 0 V='abs(v(x_dut.cg_20)-v(vddh_ii))'
Bsp_st35gs sp_st35gs 0 V='abs(v(x_dut.cg_20)-v(vddh_ii))'
Bsp_st35gd sp_st35gd 0 V='abs(v(x_dut.cg_20)-v(x_dut.cgb_20))'
Bsp_st35ds sp_st35ds 0 V='abs(v(x_dut.cgb_20)-v(vddh_ii))'
Bsp_st36gs sp_st36gs 0 V='abs(v(x_dut.cg_20)-v(x_dut.bl_20))'
Bsp_st36gd sp_st36gd 0 V='abs(v(x_dut.cg_20)-v(blg_ii))'
Bsp_st36ds sp_st36ds 0 V='abs(v(blg_ii)-v(x_dut.bl_20))'
Bsp_st37gs sp_st37gs 0 V='abs(v(csel_21)-v(0))'
Bsp_st37gd sp_st37gd 0 V='abs(v(csel_21)-v(x_dut.cgb_21))'
Bsp_st37ds sp_st37ds 0 V='abs(v(x_dut.cgb_21)-v(0))'
Bsp_st38gs sp_st38gs 0 V='abs(v(x_dut.xlc_21.inb)-v(0))'
Bsp_st38gd sp_st38gd 0 V='abs(v(x_dut.xlc_21.inb)-v(x_dut.cg_21))'
Bsp_st38ds sp_st38ds 0 V='abs(v(x_dut.cg_21)-v(0))'
Bsp_st39gs sp_st39gs 0 V='abs(v(x_dut.cgb_21)-v(vddh_ii))'
Bsp_st39gd sp_st39gd 0 V='abs(v(x_dut.cgb_21)-v(x_dut.cg_21))'
Bsp_st39ds sp_st39ds 0 V='abs(v(x_dut.cg_21)-v(vddh_ii))'
Bsp_st40gs sp_st40gs 0 V='abs(v(x_dut.cg_21)-v(vddh_ii))'
Bsp_st40gd sp_st40gd 0 V='abs(v(x_dut.cg_21)-v(x_dut.cgb_21))'
Bsp_st40ds sp_st40ds 0 V='abs(v(x_dut.cgb_21)-v(vddh_ii))'
Bsp_st41gs sp_st41gs 0 V='abs(v(x_dut.cg_21)-v(x_dut.bl_21))'
Bsp_st41gd sp_st41gd 0 V='abs(v(x_dut.cg_21)-v(blg_ii))'
Bsp_st41ds sp_st41ds 0 V='abs(v(blg_ii)-v(x_dut.bl_21))'
Bsp_st42gs sp_st42gs 0 V='abs(v(csel_22)-v(0))'
Bsp_st42gd sp_st42gd 0 V='abs(v(csel_22)-v(x_dut.cgb_22))'
Bsp_st42ds sp_st42ds 0 V='abs(v(x_dut.cgb_22)-v(0))'
Bsp_st43gs sp_st43gs 0 V='abs(v(x_dut.xlc_22.inb)-v(0))'
Bsp_st43gd sp_st43gd 0 V='abs(v(x_dut.xlc_22.inb)-v(x_dut.cg_22))'
Bsp_st43ds sp_st43ds 0 V='abs(v(x_dut.cg_22)-v(0))'
Bsp_st44gs sp_st44gs 0 V='abs(v(x_dut.cgb_22)-v(vddh_iii))'
Bsp_st44gd sp_st44gd 0 V='abs(v(x_dut.cgb_22)-v(x_dut.cg_22))'
Bsp_st44ds sp_st44ds 0 V='abs(v(x_dut.cg_22)-v(vddh_iii))'
Bsp_st45gs sp_st45gs 0 V='abs(v(x_dut.cg_22)-v(vddh_iii))'
Bsp_st45gd sp_st45gd 0 V='abs(v(x_dut.cg_22)-v(x_dut.cgb_22))'
Bsp_st45ds sp_st45ds 0 V='abs(v(x_dut.cgb_22)-v(vddh_iii))'
Bsp_st46gs sp_st46gs 0 V='abs(v(x_dut.cg_22)-v(x_dut.bl_22))'
Bsp_st46gd sp_st46gd 0 V='abs(v(x_dut.cg_22)-v(blg_iii))'
Bsp_st46ds sp_st46ds 0 V='abs(v(blg_iii)-v(x_dut.bl_22))'
Bsp_st47gs sp_st47gs 0 V='abs(v(csel_23)-v(0))'
Bsp_st47gd sp_st47gd 0 V='abs(v(csel_23)-v(x_dut.cgb_23))'
Bsp_st47ds sp_st47ds 0 V='abs(v(x_dut.cgb_23)-v(0))'
Bsp_st48gs sp_st48gs 0 V='abs(v(x_dut.xlc_23.inb)-v(0))'
Bsp_st48gd sp_st48gd 0 V='abs(v(x_dut.xlc_23.inb)-v(x_dut.cg_23))'
Bsp_st48ds sp_st48ds 0 V='abs(v(x_dut.cg_23)-v(0))'
Bsp_st49gs sp_st49gs 0 V='abs(v(x_dut.cgb_23)-v(vddh_iii))'
Bsp_st49gd sp_st49gd 0 V='abs(v(x_dut.cgb_23)-v(x_dut.cg_23))'
Bsp_st49ds sp_st49ds 0 V='abs(v(x_dut.cg_23)-v(vddh_iii))'
Bsp_st50gs sp_st50gs 0 V='abs(v(x_dut.cg_23)-v(vddh_iii))'
Bsp_st50gd sp_st50gd 0 V='abs(v(x_dut.cg_23)-v(x_dut.cgb_23))'
Bsp_st50ds sp_st50ds 0 V='abs(v(x_dut.cgb_23)-v(vddh_iii))'
Bsp_st51gs sp_st51gs 0 V='abs(v(x_dut.cg_23)-v(x_dut.bl_23))'
Bsp_st51gd sp_st51gd 0 V='abs(v(x_dut.cg_23)-v(blg_iii))'
Bsp_st51ds sp_st51ds 0 V='abs(v(blg_iii)-v(x_dut.bl_23))'
Bsp_st52gs sp_st52gs 0 V='abs(v(rsel_0)-v(0))'
Bsp_st52gd sp_st52gd 0 V='abs(v(rsel_0)-v(x_dut.rgb_0_ii))'
Bsp_st52ds sp_st52ds 0 V='abs(v(x_dut.rgb_0_ii)-v(0))'
Bsp_st53gs sp_st53gs 0 V='abs(v(x_dut.xlr_0_ii.inb)-v(0))'
Bsp_st53gd sp_st53gd 0 V='abs(v(x_dut.xlr_0_ii.inb)-v(x_dut.wl_0_ii))'
Bsp_st53ds sp_st53ds 0 V='abs(v(x_dut.wl_0_ii)-v(0))'
Bsp_st54gs sp_st54gs 0 V='abs(v(x_dut.rgb_0_ii)-v(vddh_ii))'
Bsp_st54gd sp_st54gd 0 V='abs(v(x_dut.rgb_0_ii)-v(x_dut.wl_0_ii))'
Bsp_st54ds sp_st54ds 0 V='abs(v(x_dut.wl_0_ii)-v(vddh_ii))'
Bsp_st55gs sp_st55gs 0 V='abs(v(x_dut.wl_0_ii)-v(vddh_ii))'
Bsp_st55gd sp_st55gd 0 V='abs(v(x_dut.wl_0_ii)-v(x_dut.rgb_0_ii))'
Bsp_st55ds sp_st55ds 0 V='abs(v(x_dut.rgb_0_ii)-v(vddh_ii))'
Bsp_st56gs sp_st56gs 0 V='abs(v(x_dut.wl_0_ii)-v(plg_ii))'
Bsp_st56gd sp_st56gd 0 V='abs(v(x_dut.wl_0_ii)-v(x_dut.pl_0_ii))'
Bsp_st56ds sp_st56ds 0 V='abs(v(x_dut.pl_0_ii)-v(plg_ii))'
Bsp_st57gs sp_st57gs 0 V='abs(v(rsel_1)-v(0))'
Bsp_st57gd sp_st57gd 0 V='abs(v(rsel_1)-v(x_dut.rgb_1_ii))'
Bsp_st57ds sp_st57ds 0 V='abs(v(x_dut.rgb_1_ii)-v(0))'
Bsp_st58gs sp_st58gs 0 V='abs(v(x_dut.xlr_1_ii.inb)-v(0))'
Bsp_st58gd sp_st58gd 0 V='abs(v(x_dut.xlr_1_ii.inb)-v(x_dut.wl_1_ii))'
Bsp_st58ds sp_st58ds 0 V='abs(v(x_dut.wl_1_ii)-v(0))'
Bsp_st59gs sp_st59gs 0 V='abs(v(x_dut.rgb_1_ii)-v(vddh_ii))'
Bsp_st59gd sp_st59gd 0 V='abs(v(x_dut.rgb_1_ii)-v(x_dut.wl_1_ii))'
Bsp_st59ds sp_st59ds 0 V='abs(v(x_dut.wl_1_ii)-v(vddh_ii))'
Bsp_st60gs sp_st60gs 0 V='abs(v(x_dut.wl_1_ii)-v(vddh_ii))'
Bsp_st60gd sp_st60gd 0 V='abs(v(x_dut.wl_1_ii)-v(x_dut.rgb_1_ii))'
Bsp_st60ds sp_st60ds 0 V='abs(v(x_dut.rgb_1_ii)-v(vddh_ii))'
Bsp_st61gs sp_st61gs 0 V='abs(v(x_dut.wl_1_ii)-v(plg_ii))'
Bsp_st61gd sp_st61gd 0 V='abs(v(x_dut.wl_1_ii)-v(x_dut.pl_1_ii))'
Bsp_st61ds sp_st61ds 0 V='abs(v(x_dut.pl_1_ii)-v(plg_ii))'
Bsp_st62gs sp_st62gs 0 V='abs(v(rsel_2)-v(0))'
Bsp_st62gd sp_st62gd 0 V='abs(v(rsel_2)-v(x_dut.rgb_2_ii))'
Bsp_st62ds sp_st62ds 0 V='abs(v(x_dut.rgb_2_ii)-v(0))'
Bsp_st63gs sp_st63gs 0 V='abs(v(x_dut.xlr_2_ii.inb)-v(0))'
Bsp_st63gd sp_st63gd 0 V='abs(v(x_dut.xlr_2_ii.inb)-v(x_dut.wl_2_ii))'
Bsp_st63ds sp_st63ds 0 V='abs(v(x_dut.wl_2_ii)-v(0))'
Bsp_st64gs sp_st64gs 0 V='abs(v(x_dut.rgb_2_ii)-v(vddh_ii))'
Bsp_st64gd sp_st64gd 0 V='abs(v(x_dut.rgb_2_ii)-v(x_dut.wl_2_ii))'
Bsp_st64ds sp_st64ds 0 V='abs(v(x_dut.wl_2_ii)-v(vddh_ii))'
Bsp_st65gs sp_st65gs 0 V='abs(v(x_dut.wl_2_ii)-v(vddh_ii))'
Bsp_st65gd sp_st65gd 0 V='abs(v(x_dut.wl_2_ii)-v(x_dut.rgb_2_ii))'
Bsp_st65ds sp_st65ds 0 V='abs(v(x_dut.rgb_2_ii)-v(vddh_ii))'
Bsp_st66gs sp_st66gs 0 V='abs(v(x_dut.wl_2_ii)-v(plg_ii))'
Bsp_st66gd sp_st66gd 0 V='abs(v(x_dut.wl_2_ii)-v(x_dut.pl_2_ii))'
Bsp_st66ds sp_st66ds 0 V='abs(v(x_dut.pl_2_ii)-v(plg_ii))'
Bsp_st67gs sp_st67gs 0 V='abs(v(rsel_3)-v(0))'
Bsp_st67gd sp_st67gd 0 V='abs(v(rsel_3)-v(x_dut.rgb_3_ii))'
Bsp_st67ds sp_st67ds 0 V='abs(v(x_dut.rgb_3_ii)-v(0))'
Bsp_st68gs sp_st68gs 0 V='abs(v(x_dut.xlr_3_ii.inb)-v(0))'
Bsp_st68gd sp_st68gd 0 V='abs(v(x_dut.xlr_3_ii.inb)-v(x_dut.wl_3_ii))'
Bsp_st68ds sp_st68ds 0 V='abs(v(x_dut.wl_3_ii)-v(0))'
Bsp_st69gs sp_st69gs 0 V='abs(v(x_dut.rgb_3_ii)-v(vddh_ii))'
Bsp_st69gd sp_st69gd 0 V='abs(v(x_dut.rgb_3_ii)-v(x_dut.wl_3_ii))'
Bsp_st69ds sp_st69ds 0 V='abs(v(x_dut.wl_3_ii)-v(vddh_ii))'
Bsp_st70gs sp_st70gs 0 V='abs(v(x_dut.wl_3_ii)-v(vddh_ii))'
Bsp_st70gd sp_st70gd 0 V='abs(v(x_dut.wl_3_ii)-v(x_dut.rgb_3_ii))'
Bsp_st70ds sp_st70ds 0 V='abs(v(x_dut.rgb_3_ii)-v(vddh_ii))'
Bsp_st71gs sp_st71gs 0 V='abs(v(x_dut.wl_3_ii)-v(plg_ii))'
Bsp_st71gd sp_st71gd 0 V='abs(v(x_dut.wl_3_ii)-v(x_dut.pl_3_ii))'
Bsp_st71ds sp_st71ds 0 V='abs(v(x_dut.pl_3_ii)-v(plg_ii))'
Bsp_st72gs sp_st72gs 0 V='abs(v(rsel_0)-v(0))'
Bsp_st72gd sp_st72gd 0 V='abs(v(rsel_0)-v(x_dut.wl_0_iii))'
Bsp_st72ds sp_st72ds 0 V='abs(v(x_dut.wl_0_iii)-v(0))'
Bsp_st73gs sp_st73gs 0 V='abs(v(x_dut.xlr_0_iii.inb)-v(0))'
Bsp_st73gd sp_st73gd 0 V='abs(v(x_dut.xlr_0_iii.inb)-v(x_dut.rg_0_iii))'
Bsp_st73ds sp_st73ds 0 V='abs(v(x_dut.rg_0_iii)-v(0))'
Bsp_st74gs sp_st74gs 0 V='abs(v(x_dut.wl_0_iii)-v(vddh_iii))'
Bsp_st74gd sp_st74gd 0 V='abs(v(x_dut.wl_0_iii)-v(x_dut.rg_0_iii))'
Bsp_st74ds sp_st74ds 0 V='abs(v(x_dut.rg_0_iii)-v(vddh_iii))'
Bsp_st75gs sp_st75gs 0 V='abs(v(x_dut.rg_0_iii)-v(vddh_iii))'
Bsp_st75gd sp_st75gd 0 V='abs(v(x_dut.rg_0_iii)-v(x_dut.wl_0_iii))'
Bsp_st75ds sp_st75ds 0 V='abs(v(x_dut.wl_0_iii)-v(vddh_iii))'
Bsp_st76gs sp_st76gs 0 V='abs(v(x_dut.rg_0_iii)-v(plg_iii))'
Bsp_st76gd sp_st76gd 0 V='abs(v(x_dut.rg_0_iii)-v(x_dut.pl_0_iii))'
Bsp_st76ds sp_st76ds 0 V='abs(v(x_dut.pl_0_iii)-v(plg_iii))'
Bsp_st77gs sp_st77gs 0 V='abs(v(rsel_1)-v(0))'
Bsp_st77gd sp_st77gd 0 V='abs(v(rsel_1)-v(x_dut.wl_1_iii))'
Bsp_st77ds sp_st77ds 0 V='abs(v(x_dut.wl_1_iii)-v(0))'
Bsp_st78gs sp_st78gs 0 V='abs(v(x_dut.xlr_1_iii.inb)-v(0))'
Bsp_st78gd sp_st78gd 0 V='abs(v(x_dut.xlr_1_iii.inb)-v(x_dut.rg_1_iii))'
Bsp_st78ds sp_st78ds 0 V='abs(v(x_dut.rg_1_iii)-v(0))'
Bsp_st79gs sp_st79gs 0 V='abs(v(x_dut.wl_1_iii)-v(vddh_iii))'
Bsp_st79gd sp_st79gd 0 V='abs(v(x_dut.wl_1_iii)-v(x_dut.rg_1_iii))'
Bsp_st79ds sp_st79ds 0 V='abs(v(x_dut.rg_1_iii)-v(vddh_iii))'
Bsp_st80gs sp_st80gs 0 V='abs(v(x_dut.rg_1_iii)-v(vddh_iii))'
Bsp_st80gd sp_st80gd 0 V='abs(v(x_dut.rg_1_iii)-v(x_dut.wl_1_iii))'
Bsp_st80ds sp_st80ds 0 V='abs(v(x_dut.wl_1_iii)-v(vddh_iii))'
Bsp_st81gs sp_st81gs 0 V='abs(v(x_dut.rg_1_iii)-v(plg_iii))'
Bsp_st81gd sp_st81gd 0 V='abs(v(x_dut.rg_1_iii)-v(x_dut.pl_1_iii))'
Bsp_st81ds sp_st81ds 0 V='abs(v(x_dut.pl_1_iii)-v(plg_iii))'
Bsp_st82gs sp_st82gs 0 V='abs(v(rsel_2)-v(0))'
Bsp_st82gd sp_st82gd 0 V='abs(v(rsel_2)-v(x_dut.wl_2_iii))'
Bsp_st82ds sp_st82ds 0 V='abs(v(x_dut.wl_2_iii)-v(0))'
Bsp_st83gs sp_st83gs 0 V='abs(v(x_dut.xlr_2_iii.inb)-v(0))'
Bsp_st83gd sp_st83gd 0 V='abs(v(x_dut.xlr_2_iii.inb)-v(x_dut.rg_2_iii))'
Bsp_st83ds sp_st83ds 0 V='abs(v(x_dut.rg_2_iii)-v(0))'
Bsp_st84gs sp_st84gs 0 V='abs(v(x_dut.wl_2_iii)-v(vddh_iii))'
Bsp_st84gd sp_st84gd 0 V='abs(v(x_dut.wl_2_iii)-v(x_dut.rg_2_iii))'
Bsp_st84ds sp_st84ds 0 V='abs(v(x_dut.rg_2_iii)-v(vddh_iii))'
Bsp_st85gs sp_st85gs 0 V='abs(v(x_dut.rg_2_iii)-v(vddh_iii))'
Bsp_st85gd sp_st85gd 0 V='abs(v(x_dut.rg_2_iii)-v(x_dut.wl_2_iii))'
Bsp_st85ds sp_st85ds 0 V='abs(v(x_dut.wl_2_iii)-v(vddh_iii))'
Bsp_st86gs sp_st86gs 0 V='abs(v(x_dut.rg_2_iii)-v(plg_iii))'
Bsp_st86gd sp_st86gd 0 V='abs(v(x_dut.rg_2_iii)-v(x_dut.pl_2_iii))'
Bsp_st86ds sp_st86ds 0 V='abs(v(x_dut.pl_2_iii)-v(plg_iii))'
Bsp_st87gs sp_st87gs 0 V='abs(v(rsel_3)-v(0))'
Bsp_st87gd sp_st87gd 0 V='abs(v(rsel_3)-v(x_dut.wl_3_iii))'
Bsp_st87ds sp_st87ds 0 V='abs(v(x_dut.wl_3_iii)-v(0))'
Bsp_st88gs sp_st88gs 0 V='abs(v(x_dut.xlr_3_iii.inb)-v(0))'
Bsp_st88gd sp_st88gd 0 V='abs(v(x_dut.xlr_3_iii.inb)-v(x_dut.rg_3_iii))'
Bsp_st88ds sp_st88ds 0 V='abs(v(x_dut.rg_3_iii)-v(0))'
Bsp_st89gs sp_st89gs 0 V='abs(v(x_dut.wl_3_iii)-v(vddh_iii))'
Bsp_st89gd sp_st89gd 0 V='abs(v(x_dut.wl_3_iii)-v(x_dut.rg_3_iii))'
Bsp_st89ds sp_st89ds 0 V='abs(v(x_dut.rg_3_iii)-v(vddh_iii))'
Bsp_st90gs sp_st90gs 0 V='abs(v(x_dut.rg_3_iii)-v(vddh_iii))'
Bsp_st90gd sp_st90gd 0 V='abs(v(x_dut.rg_3_iii)-v(x_dut.wl_3_iii))'
Bsp_st90ds sp_st90ds 0 V='abs(v(x_dut.wl_3_iii)-v(vddh_iii))'
Bsp_st91gs sp_st91gs 0 V='abs(v(x_dut.rg_3_iii)-v(plg_iii))'
Bsp_st91gd sp_st91gd 0 V='abs(v(x_dut.rg_3_iii)-v(x_dut.pl_3_iii))'
Bsp_st91ds sp_st91ds 0 V='abs(v(x_dut.pl_3_iii)-v(plg_iii))'
Bsp_st92gs sp_st92gs 0 V='abs(v(xpg_ii.pgb)-v(vpp))'
Bsp_st92gd sp_st92gd 0 V='abs(v(xpg_ii.pgb)-v(xpg_ii.pg))'
Bsp_st92ds sp_st92ds 0 V='abs(v(xpg_ii.pg)-v(vpp))'
Bsp_st93gs sp_st93gs 0 V='abs(v(xpg_ii.pg)-v(vpp))'
Bsp_st93gd sp_st93gd 0 V='abs(v(xpg_ii.pg)-v(xpg_ii.pgb))'
Bsp_st93ds sp_st93ds 0 V='abs(v(xpg_ii.pgb)-v(vpp))'
Bsp_st94gs sp_st94gs 0 V='abs(v(xpg_ii.pon)-v(0))'
Bsp_st94gd sp_st94gd 0 V='abs(v(xpg_ii.pon)-v(xpg_ii.pg))'
Bsp_st94ds sp_st94ds 0 V='abs(v(xpg_ii.pg)-v(0))'
Bsp_st95gs sp_st95gs 0 V='abs(v(xpg_ii.ponb)-v(0))'
Bsp_st95gd sp_st95gd 0 V='abs(v(xpg_ii.ponb)-v(xpg_ii.pgb))'
Bsp_st95ds sp_st95ds 0 V='abs(v(xpg_ii.pgb)-v(0))'
Bsp_st96gs sp_st96gs 0 V='abs(v(xpg_ii.pg)-v(vpp))'
Bsp_st96gd sp_st96gd 0 V='abs(v(xpg_ii.pg)-v(xpg_ii.rb_top))'
Bsp_st96ds sp_st96ds 0 V='abs(v(xpg_ii.rb_top)-v(vpp))'
Bsp_st97t12 sp_st97t12 0 V='abs(v(blp_ii)-v(xpg_ii.rb_top))'
Bsp_st98gs sp_st98gs 0 V='abs(v(xrd_ii.ron)-v(blr_ii))'
Bsp_st98gd sp_st98gd 0 V='abs(v(xrd_ii.ron)-v(xrd_ii.cs))'
Bsp_st98ds sp_st98ds 0 V='abs(v(xrd_ii.cs)-v(blr_ii))'
Bsp_st99gs sp_st99gs 0 V='abs(v(vclamp)-v(xrd_ii.cs))'
Bsp_st99gd sp_st99gd 0 V='abs(v(vclamp)-v(xrd_ii.pin))'
Bsp_st99ds sp_st99ds 0 V='abs(v(xrd_ii.pin)-v(xrd_ii.cs))'
Bsp_st100gs sp_st100gs 0 V='abs(v(xrd_ii.pin)-v(vdd))'
Bsp_st100gd sp_st100gd 0 V='abs(v(xrd_ii.pin)-v(xrd_ii.pin))'
Bsp_st100ds sp_st100ds 0 V='abs(v(xrd_ii.pin)-v(vdd))'
Bsp_st101gs sp_st101gs 0 V='abs(v(xrd_ii.pin)-v(vdd))'
Bsp_st101gd sp_st101gd 0 V='abs(v(xrd_ii.pin)-v(sense_ii))'
Bsp_st101ds sp_st101ds 0 V='abs(v(sense_ii)-v(vdd))'
Bsp_st102gs sp_st102gs 0 V='abs(v(iref_ii)-v(0))'
Bsp_st102gd sp_st102gd 0 V='abs(v(iref_ii)-v(iref_ii))'
Bsp_st102ds sp_st102ds 0 V='abs(v(iref_ii)-v(0))'
Bsp_st103gs sp_st103gs 0 V='abs(v(iref_ii)-v(0))'
Bsp_st103gd sp_st103gd 0 V='abs(v(iref_ii)-v(sense_ii))'
Bsp_st103ds sp_st103ds 0 V='abs(v(sense_ii)-v(0))'
Bsp_st104gs sp_st104gs 0 V='abs(v(xpg_iii.pgb)-v(vpp))'
Bsp_st104gd sp_st104gd 0 V='abs(v(xpg_iii.pgb)-v(xpg_iii.pg))'
Bsp_st104ds sp_st104ds 0 V='abs(v(xpg_iii.pg)-v(vpp))'
Bsp_st105gs sp_st105gs 0 V='abs(v(xpg_iii.pg)-v(vpp))'
Bsp_st105gd sp_st105gd 0 V='abs(v(xpg_iii.pg)-v(xpg_iii.pgb))'
Bsp_st105ds sp_st105ds 0 V='abs(v(xpg_iii.pgb)-v(vpp))'
Bsp_st106gs sp_st106gs 0 V='abs(v(xpg_iii.pon)-v(0))'
Bsp_st106gd sp_st106gd 0 V='abs(v(xpg_iii.pon)-v(xpg_iii.pg))'
Bsp_st106ds sp_st106ds 0 V='abs(v(xpg_iii.pg)-v(0))'
Bsp_st107gs sp_st107gs 0 V='abs(v(xpg_iii.ponb)-v(0))'
Bsp_st107gd sp_st107gd 0 V='abs(v(xpg_iii.ponb)-v(xpg_iii.pgb))'
Bsp_st107ds sp_st107ds 0 V='abs(v(xpg_iii.pgb)-v(0))'
Bsp_st108gs sp_st108gs 0 V='abs(v(xpg_iii.pg)-v(vpp))'
Bsp_st108gd sp_st108gd 0 V='abs(v(xpg_iii.pg)-v(xpg_iii.rb_top))'
Bsp_st108ds sp_st108ds 0 V='abs(v(xpg_iii.rb_top)-v(vpp))'
Bsp_st109t12 sp_st109t12 0 V='abs(v(blp_iii)-v(xpg_iii.rb_top))'
Bsp_st110gs sp_st110gs 0 V='abs(v(xrd_iii.ron)-v(blr_iii))'
Bsp_st110gd sp_st110gd 0 V='abs(v(xrd_iii.ron)-v(xrd_iii.cs))'
Bsp_st110ds sp_st110ds 0 V='abs(v(xrd_iii.cs)-v(blr_iii))'
Bsp_st111gs sp_st111gs 0 V='abs(v(vclamp)-v(xrd_iii.cs))'
Bsp_st111gd sp_st111gd 0 V='abs(v(vclamp)-v(xrd_iii.pin))'
Bsp_st111ds sp_st111ds 0 V='abs(v(xrd_iii.pin)-v(xrd_iii.cs))'
Bsp_st112gs sp_st112gs 0 V='abs(v(xrd_iii.pin)-v(vdd))'
Bsp_st112gd sp_st112gd 0 V='abs(v(xrd_iii.pin)-v(xrd_iii.pin))'
Bsp_st112ds sp_st112ds 0 V='abs(v(xrd_iii.pin)-v(vdd))'
Bsp_st113gs sp_st113gs 0 V='abs(v(xrd_iii.pin)-v(vdd))'
Bsp_st113gd sp_st113gd 0 V='abs(v(xrd_iii.pin)-v(sense_iii))'
Bsp_st113ds sp_st113ds 0 V='abs(v(sense_iii)-v(vdd))'
Bsp_st114gs sp_st114gs 0 V='abs(v(iref_iii)-v(0))'
Bsp_st114gd sp_st114gd 0 V='abs(v(iref_iii)-v(iref_iii))'
Bsp_st114ds sp_st114ds 0 V='abs(v(iref_iii)-v(0))'
Bsp_st115gs sp_st115gs 0 V='abs(v(iref_iii)-v(0))'
Bsp_st115gd sp_st115gd 0 V='abs(v(iref_iii)-v(sense_iii))'
Bsp_st115ds sp_st115ds 0 V='abs(v(sense_iii)-v(0))'
