* klt sim -- generated corner deck, do not edit
.lib /opt/pdk/gf180mcuD/libs.tech/ngspice/sm141064.ngspice typical
.lib /opt/pdk/gf180mcuD/libs.tech/ngspice/sm141064.ngspice moscap_typical
.include /var/tmp/eda-job-klt-sim-7992e604c501/inputs/netlist.cir
.temp -40.0
.meas tran mx_ox MAX v(dox)
.meas tran mn_ox MIN v(dox)
.meas tran mx_wc MAX v(dwc)
.meas tran mn_wc MIN v(dwc)
.meas tran mx_wb MAX v(dwb)
.meas tran mn_wb MIN v(dwb)
.meas tran mx_bc MAX v(dbc)
.meas tran mn_bc MIN v(dbc)
.meas tran mx_cj MAX v(dcj)
.meas tran mn_cj MIN v(dcj)
.meas tran mx_bj MAX v(dbj)
.meas tran mn_bj MIN v(dbj)
.meas tran mx_gb MAX v(dgb)
.meas tran mn_gb MIN v(dgb)
.meas tran vox_mid FIND v(dox) AT=6.100000e-06
.meas tran vcn_mid FIND v(xdut.xc.cn) AT=6.100000e-06
.meas tran vcn_end FIND v(xdut.xc.cn) AT=1.990000e-05
.meas tran ipl_mid FIND i(vplm) AT=6.100000e-06
.meas tran ipl_mx MAX i(vplm)
.meas tran ipl_mn MIN i(vplm)
.meas tran st FIND v(xdut.xbd.st) AT=1.990000e-05
.meas tran st_mid FIND v(xdut.xbd.st) AT=6.100000e-06
.control
save all
alter vamp=-7.505
tran 1.000000e-08 2.000000e-05 uic
quit
.endc
.end
