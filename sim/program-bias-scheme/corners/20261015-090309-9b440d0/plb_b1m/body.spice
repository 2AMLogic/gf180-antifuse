* gf180-antifuse sim/cell-breakdown-model -- Candidate 2 plb_b1m (tran, #90)
* Generated by run_experiment.py; frozen here as evidence. See README.
* --- inlined from gf180mcuD/libs.tech/ngspice/design.ngspice (sha256 091cb530bf85160a1f07878fb81f789ca367d018991c8ab41a584cd1a85c6692) ---
.param
+  sw_stat_global = 0
+  sw_stat_mismatch = 0
+ mc_skew = 3
+ res_mc_skew = 3
+ cap_mc_skew = 3
+  fnoicor = 0
* --- end inline ---
.lib /opt/pdk/gf180mcuD/libs.tech/ngspice/smbb000149.ngspice typical
.options gmin=1.000000e-13
.include ../../../../../design/breakdown/cell_candidates_bd.spice

.param t1=1.000000e-06 tr=1.000000e-07 tw=1.000000e-05
.func af_fe(u) {exp(-1/max(u,1e-6))}
.func af_edge(x) {af_fe(min(max(x,0),1))/(af_fe(min(max(x,0),1))+af_fe(1-min(max(x,0),1)))}
BSH SH 0 V = 'af_edge((time-t1)/tr) - af_edge((time-t1-tr-tw)/tr)'
VAMP AMP 0 DC 0
BVPP VPP 0 V = 'v(amp)*v(sh)'
RBAL VPP PLM 3.040000e+04
VPLM PLM PL DC 0
VBL BL 0 DC 0
BWL WL 0 V = '5.000000e+00*af_edge(time/4.000000e-07)'
BVB VB 0 V = '0.000000e+00*af_edge(time/4.000000e-07)'
XDUT BL WL PL VB cell_candidate2_bd wcap=1.000000e-06 lcap=1.000000e-06 wacc=2.500000e-05 lacc=6.000000e-07 bden=1 prog=0 dyn=1 ubd=0.5
BDOX DOX 0 V = 'v(xdut.xc.cn)-v(pl)'
BDWC DWC 0 V = 'v(wl)-v(xdut.xc.cn)'
BDWB DWB 0 V = 'v(wl)-v(bl)'
BDBC DBC 0 V = 'v(bl)-v(xdut.xc.cn)'
BDCJ DCJ 0 V = 'v(xdut.xc.cn)-v(vb)'
BDBJ DBJ 0 V = 'v(bl)-v(vb)'
BDGB DGB 0 V = 'v(wl)-v(vb)'
