* klt sim -- generated corner deck, do not edit
.lib /opt/pdk/gf180mcuD/libs.tech/ngspice/sm141064.ngspice typical
.lib /opt/pdk/gf180mcuD/libs.tech/ngspice/sm141064.ngspice moscap_typical
.include /var/tmp/eda-job-klt-sim-b26478505ff3/inputs/netlist.cir
.temp -40.0
.meas dc i_st_s1g1_1 FIND i(vm_st_s1g1_1) AT=0.000000e+00
.meas dc i_b0_s1g1_1 FIND i(vm_b0_s1g1_1) AT=0.000000e+00
.meas dc i_b1_s1g1_1 FIND i(vm_b1_s1g1_1) AT=0.000000e+00
.meas dc i_st_s1g1_2 FIND i(vm_st_s1g1_2) AT=0.000000e+00
.meas dc i_b0_s1g1_2 FIND i(vm_b0_s1g1_2) AT=0.000000e+00
.meas dc i_b1_s1g1_2 FIND i(vm_b1_s1g1_2) AT=0.000000e+00
.meas dc i_st_s1g1_3 FIND i(vm_st_s1g1_3) AT=0.000000e+00
.meas dc i_b0_s1g1_3 FIND i(vm_b0_s1g1_3) AT=0.000000e+00
.meas dc i_b1_s1g1_3 FIND i(vm_b1_s1g1_3) AT=0.000000e+00
.meas dc i_st_s1g1_4 FIND i(vm_st_s1g1_4) AT=0.000000e+00
.meas dc i_b0_s1g1_4 FIND i(vm_b0_s1g1_4) AT=0.000000e+00
.meas dc i_b1_s1g1_4 FIND i(vm_b1_s1g1_4) AT=0.000000e+00
.meas dc i_st_s1g1_5 FIND i(vm_st_s1g1_5) AT=0.000000e+00
.meas dc i_b0_s1g1_5 FIND i(vm_b0_s1g1_5) AT=0.000000e+00
.meas dc i_b1_s1g1_5 FIND i(vm_b1_s1g1_5) AT=0.000000e+00
.meas dc i_st_s1g2_1 FIND i(vm_st_s1g2_1) AT=0.000000e+00
.meas dc i_b0_s1g2_1 FIND i(vm_b0_s1g2_1) AT=0.000000e+00
.meas dc i_b1_s1g2_1 FIND i(vm_b1_s1g2_1) AT=0.000000e+00
.meas dc i_st_s1g2_2 FIND i(vm_st_s1g2_2) AT=0.000000e+00
.meas dc i_b0_s1g2_2 FIND i(vm_b0_s1g2_2) AT=0.000000e+00
.meas dc i_b1_s1g2_2 FIND i(vm_b1_s1g2_2) AT=0.000000e+00
.meas dc i_st_s1g2_3 FIND i(vm_st_s1g2_3) AT=0.000000e+00
.meas dc i_b0_s1g2_3 FIND i(vm_b0_s1g2_3) AT=0.000000e+00
.meas dc i_b1_s1g2_3 FIND i(vm_b1_s1g2_3) AT=0.000000e+00
.meas dc i_st_s1g2_4 FIND i(vm_st_s1g2_4) AT=0.000000e+00
.meas dc i_b0_s1g2_4 FIND i(vm_b0_s1g2_4) AT=0.000000e+00
.meas dc i_b1_s1g2_4 FIND i(vm_b1_s1g2_4) AT=0.000000e+00
.meas dc i_st_s1g2_5 FIND i(vm_st_s1g2_5) AT=0.000000e+00
.meas dc i_b0_s1g2_5 FIND i(vm_b0_s1g2_5) AT=0.000000e+00
.meas dc i_b1_s1g2_5 FIND i(vm_b1_s1g2_5) AT=0.000000e+00
.meas dc i_st_s2g1_1 FIND i(vm_st_s2g1_1) AT=0.000000e+00
.meas dc i_b0_s2g1_1 FIND i(vm_b0_s2g1_1) AT=0.000000e+00
.meas dc i_b1_s2g1_1 FIND i(vm_b1_s2g1_1) AT=0.000000e+00
.meas dc i_st_s2g1_2 FIND i(vm_st_s2g1_2) AT=0.000000e+00
.meas dc i_b0_s2g1_2 FIND i(vm_b0_s2g1_2) AT=0.000000e+00
.meas dc i_b1_s2g1_2 FIND i(vm_b1_s2g1_2) AT=0.000000e+00
.meas dc i_st_s2g1_3 FIND i(vm_st_s2g1_3) AT=0.000000e+00
.meas dc i_b0_s2g1_3 FIND i(vm_b0_s2g1_3) AT=0.000000e+00
.meas dc i_b1_s2g1_3 FIND i(vm_b1_s2g1_3) AT=0.000000e+00
.meas dc i_st_s2g1_4 FIND i(vm_st_s2g1_4) AT=0.000000e+00
.meas dc i_b0_s2g1_4 FIND i(vm_b0_s2g1_4) AT=0.000000e+00
.meas dc i_b1_s2g1_4 FIND i(vm_b1_s2g1_4) AT=0.000000e+00
.meas dc i_st_s2g1_5 FIND i(vm_st_s2g1_5) AT=0.000000e+00
.meas dc i_b0_s2g1_5 FIND i(vm_b0_s2g1_5) AT=0.000000e+00
.meas dc i_b1_s2g1_5 FIND i(vm_b1_s2g1_5) AT=0.000000e+00
.meas dc i_st_s2g2_1 FIND i(vm_st_s2g2_1) AT=0.000000e+00
.meas dc i_b0_s2g2_1 FIND i(vm_b0_s2g2_1) AT=0.000000e+00
.meas dc i_b1_s2g2_1 FIND i(vm_b1_s2g2_1) AT=0.000000e+00
.meas dc i_st_s2g2_2 FIND i(vm_st_s2g2_2) AT=0.000000e+00
.meas dc i_b0_s2g2_2 FIND i(vm_b0_s2g2_2) AT=0.000000e+00
.meas dc i_b1_s2g2_2 FIND i(vm_b1_s2g2_2) AT=0.000000e+00
.meas dc i_st_s2g2_3 FIND i(vm_st_s2g2_3) AT=0.000000e+00
.meas dc i_b0_s2g2_3 FIND i(vm_b0_s2g2_3) AT=0.000000e+00
.meas dc i_b1_s2g2_3 FIND i(vm_b1_s2g2_3) AT=0.000000e+00
.meas dc i_st_s2g2_4 FIND i(vm_st_s2g2_4) AT=0.000000e+00
.meas dc i_b0_s2g2_4 FIND i(vm_b0_s2g2_4) AT=0.000000e+00
.meas dc i_b1_s2g2_4 FIND i(vm_b1_s2g2_4) AT=0.000000e+00
.meas dc i_st_s2g2_5 FIND i(vm_st_s2g2_5) AT=0.000000e+00
.meas dc i_b0_s2g2_5 FIND i(vm_b0_s2g2_5) AT=0.000000e+00
.meas dc i_b1_s2g2_5 FIND i(vm_b1_s2g2_5) AT=0.000000e+00
.control
save all
dc VDMY -1 1 1
quit
.endc
.end
