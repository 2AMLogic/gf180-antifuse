* gf180-antifuse sim/cell-breakdown-model -- Candidate 2 prog bench, variant b1l (tran, #74)
* Generated by run_experiment.py; frozen here as evidence. See README.
* --- inlined from gf180mcuD/libs.tech/ngspice/design.ngspice (sha256 7e222f050318388f37543a64fbd0be55cc15e4b93f57501a09f7c159c4c9e561) ---
.param sw_stat_global=0
.param sw_stat_mismatch=0
.param mc_skew=3
.param res_mc_skew=3
.param cap_mc_skew=3
.param fnoicor=0
* --- end inline ---
.lib /home/ubuntu/.ciel/gf180mcuD/libs.tech/ngspice/smbb000149.ngspice typical
.options gmin=1.000000e-13
.include ../../../../../design/breakdown/cell_candidates_bd.spice

.param t1=1.000000e-06 tr=1.000000e-07 tw=1.000000e-05
BSH SH 0 V = '0.5*(1-cos(pi*min(max((time-t1)/tr,0),1))) - 0.5*(1-cos(pi*min(max((time-t1-tr-tw)/tr,0),1)))'
VAMP AMP 0 DC 0
BVPP VPP 0 V = 'v(amp)*v(sh)'
RBAL VPP BLM 3.040000e+04
VBL BLM BL DC 0
BWL WL 0 V = '5.000000e+00 + v(vpp)'
VVB VB 0 DC 0.000000e+00
VPL PL 0 DC 0
XDUT BL WL PL VB cell_candidate2_bd wcap=1.000000e-06 lcap=1.000000e-06 wacc=2.500000e-05 lacc=6.000000e-07 bden=1 prog=0 dyn=1 ubd=0.01
BDOX DOX 0 V = 'v(xdut.xc.cn)-v(pl)'
BDWC DWC 0 V = 'v(wl)-v(xdut.xc.cn)'
BDWB DWB 0 V = 'v(wl)-v(bl)'
BDBC DBC 0 V = 'v(bl)-v(xdut.xc.cn)'
BDCJ DCJ 0 V = 'v(xdut.xc.cn)-v(vb)'
BDBJ DBJ 0 V = 'v(bl)-v(vb)'
BDGB DGB 0 V = 'v(wl)-v(vb)'
