* gf180-antifuse sim/cell-breakdown-model -- Candidate 2 access bench (access_ac)
* Generated by run_experiment.py; frozen here as evidence. See README.
* --- inlined from gf180mcuD/libs.tech/ngspice/design.ngspice (sha256 091cb530bf85160a1f07878fb81f789ca367d018991c8ab41a584cd1a85c6692) ---
.param
+  sw_stat_global = 0
+  sw_stat_mismatch = 0
+ mc_skew = 3
+ res_mc_skew = 3
+ cap_mc_skew = 3
+  fnoicor = 0
* --- end inline ---
.lib /opt/pdk/gf180mcuD/libs.tech/ngspice/sm141064.ngspice moscap_typical
.options gmin=1.000000e-13
.include ../../../../../design/breakdown/cell_candidates_bd.spice

VBL BL 0 DC 1.000000e+00 AC 1
VVB VB 0 DC 0.000000e+00
VPL PL 0 DC 0
VWLON WLON 0 DC 5.000000e+00
VM_st_s1g1 BL B_st_s1g1 0
X_st_s1g1 B_st_s1g1 WLON PL VB cell_candidate2 wcap=1.000000e-06 lcap=1.000000e-06 wacc=2.500000e-05 lacc=6.000000e-07
H_st_s1g1 HP_st_s1g1 0 VM_st_s1g1 1
VM_b0_s1g1 BL B_b0_s1g1 0
X_b0_s1g1 B_b0_s1g1 WLON PL VB cell_candidate2_bd wcap=1.000000e-06 lcap=1.000000e-06 wacc=2.500000e-05 lacc=6.000000e-07 bden=0
H_b0_s1g1 HP_b0_s1g1 0 VM_b0_s1g1 1
VM_b1_s1g1 BL B_b1_s1g1 0
X_b1_s1g1 B_b1_s1g1 WLON PL VB cell_candidate2_bd wcap=1.000000e-06 lcap=1.000000e-06 wacc=2.500000e-05 lacc=6.000000e-07 bden=1 prog=0 dyn=0
H_b1_s1g1 HP_b1_s1g1 0 VM_b1_s1g1 1
VM_st_s1g2 BL B_st_s1g2 0
X_st_s1g2 B_st_s1g2 WLON PL VB cell_candidate2 wcap=2.000000e-06 lcap=1.000000e-06 wacc=2.500000e-05 lacc=6.000000e-07
H_st_s1g2 HP_st_s1g2 0 VM_st_s1g2 1
VM_b0_s1g2 BL B_b0_s1g2 0
X_b0_s1g2 B_b0_s1g2 WLON PL VB cell_candidate2_bd wcap=2.000000e-06 lcap=1.000000e-06 wacc=2.500000e-05 lacc=6.000000e-07 bden=0
H_b0_s1g2 HP_b0_s1g2 0 VM_b0_s1g2 1
VM_b1_s1g2 BL B_b1_s1g2 0
X_b1_s1g2 B_b1_s1g2 WLON PL VB cell_candidate2_bd wcap=2.000000e-06 lcap=1.000000e-06 wacc=2.500000e-05 lacc=6.000000e-07 bden=1 prog=0 dyn=0
H_b1_s1g2 HP_b1_s1g2 0 VM_b1_s1g2 1
VM_st_s2g1 BL B_st_s2g1 0
X_st_s2g1 B_st_s2g1 WLON PL VB cell_candidate2 wcap=1.000000e-06 lcap=1.000000e-06 wacc=5.000000e-05 lacc=6.000000e-07
H_st_s2g1 HP_st_s2g1 0 VM_st_s2g1 1
VM_b0_s2g1 BL B_b0_s2g1 0
X_b0_s2g1 B_b0_s2g1 WLON PL VB cell_candidate2_bd wcap=1.000000e-06 lcap=1.000000e-06 wacc=5.000000e-05 lacc=6.000000e-07 bden=0
H_b0_s2g1 HP_b0_s2g1 0 VM_b0_s2g1 1
VM_b1_s2g1 BL B_b1_s2g1 0
X_b1_s2g1 B_b1_s2g1 WLON PL VB cell_candidate2_bd wcap=1.000000e-06 lcap=1.000000e-06 wacc=5.000000e-05 lacc=6.000000e-07 bden=1 prog=0 dyn=0
H_b1_s2g1 HP_b1_s2g1 0 VM_b1_s2g1 1
VM_st_s2g2 BL B_st_s2g2 0
X_st_s2g2 B_st_s2g2 WLON PL VB cell_candidate2 wcap=2.000000e-06 lcap=1.000000e-06 wacc=5.000000e-05 lacc=6.000000e-07
H_st_s2g2 HP_st_s2g2 0 VM_st_s2g2 1
VM_b0_s2g2 BL B_b0_s2g2 0
X_b0_s2g2 B_b0_s2g2 WLON PL VB cell_candidate2_bd wcap=2.000000e-06 lcap=1.000000e-06 wacc=5.000000e-05 lacc=6.000000e-07 bden=0
H_b0_s2g2 HP_b0_s2g2 0 VM_b0_s2g2 1
VM_b1_s2g2 BL B_b1_s2g2 0
X_b1_s2g2 B_b1_s2g2 WLON PL VB cell_candidate2_bd wcap=2.000000e-06 lcap=1.000000e-06 wacc=5.000000e-05 lacc=6.000000e-07 bden=1 prog=0 dyn=0
H_b1_s2g2 HP_b1_s2g2 0 VM_b1_s2g2 1
