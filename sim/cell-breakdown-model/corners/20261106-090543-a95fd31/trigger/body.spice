* gf180-antifuse sim/cell-breakdown-model -- Candidate 2 trigger/latch bench (tran)
* Generated by run_experiment.py; frozen here as evidence. See README.
* --- inlined from gf180mcuD/libs.tech/ngspice/design.ngspice (sha256 7e222f050318388f37543a64fbd0be55cc15e4b93f57501a09f7c159c4c9e561) ---
.param sw_stat_global=0
.param sw_stat_mismatch=0
.param mc_skew=3
.param res_mc_skew=3
.param cap_mc_skew=3
.param fnoicor=0
* --- end inline ---
.lib /home/ubuntu/.ciel/gf180mcuD/libs.tech/ngspice/smbb000149.ngspice typical
.options gmin=1.000000e-13
.include ../../../../../design/breakdown/cell_candidates_bd.spice

.param t1=1.000000e-06 tr=1.000000e-07 tw=1.000000e-05
VBL BL 0 DC 0
VWL WL 0 DC 5.000000e+00
VVB VB 0 DC 0.000000e+00
BSH SH 0 V = '0.5*(1-cos(pi*min(max((time-t1)/tr,0),1))) - 0.5*(1-cos(pi*min(max((time-t1-tr-tw)/tr,0),1)))'
VAMPA AMPA 0 DC 0
BPLA PLA 0 V = 'v(ampa)*v(sh)'
XA BL WL PLA VB cell_candidate2_bd wcap=1.000000e-06 lcap=1.000000e-06 wacc=2.500000e-05 lacc=6.000000e-07 bden=1 prog=0 dyn=1 ubd=0.5
VAMPB AMPB 0 DC 0
BPLB PLB 0 V = 'v(ampb)*v(sh)'
XB BL WL PLB VB cell_candidate2_bd wcap=1.000000e-06 lcap=1.000000e-06 wacc=2.500000e-05 lacc=6.000000e-07 bden=1 prog=0 dyn=1 ubd=0.01
