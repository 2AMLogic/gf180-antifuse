* klt sim -- generated corner deck, do not edit
.lib /opt/pdk/gf180mcuD/libs.tech/ngspice/sm141064.ngspice typical
.lib /opt/pdk/gf180mcuD/libs.tech/ngspice/sm141064.ngspice moscap_typical
.include /var/tmp/eda-job-klt-sim-0a20007d83db/inputs/netlist.cir
.temp -40.0
.meas ac hr_st_s1g1_1 FIND vr(hp_st_s1g1_1) AT=1.000000e+03
.meas ac hi_st_s1g1_1 FIND vi(hp_st_s1g1_1) AT=1.000000e+03
.meas ac hr_b0_s1g1_1 FIND vr(hp_b0_s1g1_1) AT=1.000000e+03
.meas ac hi_b0_s1g1_1 FIND vi(hp_b0_s1g1_1) AT=1.000000e+03
.meas ac hr_b1_s1g1_1 FIND vr(hp_b1_s1g1_1) AT=1.000000e+03
.meas ac hi_b1_s1g1_1 FIND vi(hp_b1_s1g1_1) AT=1.000000e+03
.meas ac hr_st_s1g1_2 FIND vr(hp_st_s1g1_2) AT=1.000000e+03
.meas ac hi_st_s1g1_2 FIND vi(hp_st_s1g1_2) AT=1.000000e+03
.meas ac hr_b0_s1g1_2 FIND vr(hp_b0_s1g1_2) AT=1.000000e+03
.meas ac hi_b0_s1g1_2 FIND vi(hp_b0_s1g1_2) AT=1.000000e+03
.meas ac hr_b1_s1g1_2 FIND vr(hp_b1_s1g1_2) AT=1.000000e+03
.meas ac hi_b1_s1g1_2 FIND vi(hp_b1_s1g1_2) AT=1.000000e+03
.meas ac hr_st_s1g1_3 FIND vr(hp_st_s1g1_3) AT=1.000000e+03
.meas ac hi_st_s1g1_3 FIND vi(hp_st_s1g1_3) AT=1.000000e+03
.meas ac hr_b0_s1g1_3 FIND vr(hp_b0_s1g1_3) AT=1.000000e+03
.meas ac hi_b0_s1g1_3 FIND vi(hp_b0_s1g1_3) AT=1.000000e+03
.meas ac hr_b1_s1g1_3 FIND vr(hp_b1_s1g1_3) AT=1.000000e+03
.meas ac hi_b1_s1g1_3 FIND vi(hp_b1_s1g1_3) AT=1.000000e+03
.meas ac hr_st_s1g1_4 FIND vr(hp_st_s1g1_4) AT=1.000000e+03
.meas ac hi_st_s1g1_4 FIND vi(hp_st_s1g1_4) AT=1.000000e+03
.meas ac hr_b0_s1g1_4 FIND vr(hp_b0_s1g1_4) AT=1.000000e+03
.meas ac hi_b0_s1g1_4 FIND vi(hp_b0_s1g1_4) AT=1.000000e+03
.meas ac hr_b1_s1g1_4 FIND vr(hp_b1_s1g1_4) AT=1.000000e+03
.meas ac hi_b1_s1g1_4 FIND vi(hp_b1_s1g1_4) AT=1.000000e+03
.meas ac hr_st_s1g1_5 FIND vr(hp_st_s1g1_5) AT=1.000000e+03
.meas ac hi_st_s1g1_5 FIND vi(hp_st_s1g1_5) AT=1.000000e+03
.meas ac hr_b0_s1g1_5 FIND vr(hp_b0_s1g1_5) AT=1.000000e+03
.meas ac hi_b0_s1g1_5 FIND vi(hp_b0_s1g1_5) AT=1.000000e+03
.meas ac hr_b1_s1g1_5 FIND vr(hp_b1_s1g1_5) AT=1.000000e+03
.meas ac hi_b1_s1g1_5 FIND vi(hp_b1_s1g1_5) AT=1.000000e+03
.meas ac hr_st_s1g2_1 FIND vr(hp_st_s1g2_1) AT=1.000000e+03
.meas ac hi_st_s1g2_1 FIND vi(hp_st_s1g2_1) AT=1.000000e+03
.meas ac hr_b0_s1g2_1 FIND vr(hp_b0_s1g2_1) AT=1.000000e+03
.meas ac hi_b0_s1g2_1 FIND vi(hp_b0_s1g2_1) AT=1.000000e+03
.meas ac hr_b1_s1g2_1 FIND vr(hp_b1_s1g2_1) AT=1.000000e+03
.meas ac hi_b1_s1g2_1 FIND vi(hp_b1_s1g2_1) AT=1.000000e+03
.meas ac hr_st_s1g2_2 FIND vr(hp_st_s1g2_2) AT=1.000000e+03
.meas ac hi_st_s1g2_2 FIND vi(hp_st_s1g2_2) AT=1.000000e+03
.meas ac hr_b0_s1g2_2 FIND vr(hp_b0_s1g2_2) AT=1.000000e+03
.meas ac hi_b0_s1g2_2 FIND vi(hp_b0_s1g2_2) AT=1.000000e+03
.meas ac hr_b1_s1g2_2 FIND vr(hp_b1_s1g2_2) AT=1.000000e+03
.meas ac hi_b1_s1g2_2 FIND vi(hp_b1_s1g2_2) AT=1.000000e+03
.meas ac hr_st_s1g2_3 FIND vr(hp_st_s1g2_3) AT=1.000000e+03
.meas ac hi_st_s1g2_3 FIND vi(hp_st_s1g2_3) AT=1.000000e+03
.meas ac hr_b0_s1g2_3 FIND vr(hp_b0_s1g2_3) AT=1.000000e+03
.meas ac hi_b0_s1g2_3 FIND vi(hp_b0_s1g2_3) AT=1.000000e+03
.meas ac hr_b1_s1g2_3 FIND vr(hp_b1_s1g2_3) AT=1.000000e+03
.meas ac hi_b1_s1g2_3 FIND vi(hp_b1_s1g2_3) AT=1.000000e+03
.meas ac hr_st_s1g2_4 FIND vr(hp_st_s1g2_4) AT=1.000000e+03
.meas ac hi_st_s1g2_4 FIND vi(hp_st_s1g2_4) AT=1.000000e+03
.meas ac hr_b0_s1g2_4 FIND vr(hp_b0_s1g2_4) AT=1.000000e+03
.meas ac hi_b0_s1g2_4 FIND vi(hp_b0_s1g2_4) AT=1.000000e+03
.meas ac hr_b1_s1g2_4 FIND vr(hp_b1_s1g2_4) AT=1.000000e+03
.meas ac hi_b1_s1g2_4 FIND vi(hp_b1_s1g2_4) AT=1.000000e+03
.meas ac hr_st_s1g2_5 FIND vr(hp_st_s1g2_5) AT=1.000000e+03
.meas ac hi_st_s1g2_5 FIND vi(hp_st_s1g2_5) AT=1.000000e+03
.meas ac hr_b0_s1g2_5 FIND vr(hp_b0_s1g2_5) AT=1.000000e+03
.meas ac hi_b0_s1g2_5 FIND vi(hp_b0_s1g2_5) AT=1.000000e+03
.meas ac hr_b1_s1g2_5 FIND vr(hp_b1_s1g2_5) AT=1.000000e+03
.meas ac hi_b1_s1g2_5 FIND vi(hp_b1_s1g2_5) AT=1.000000e+03
.meas ac hr_st_s2g1_1 FIND vr(hp_st_s2g1_1) AT=1.000000e+03
.meas ac hi_st_s2g1_1 FIND vi(hp_st_s2g1_1) AT=1.000000e+03
.meas ac hr_b0_s2g1_1 FIND vr(hp_b0_s2g1_1) AT=1.000000e+03
.meas ac hi_b0_s2g1_1 FIND vi(hp_b0_s2g1_1) AT=1.000000e+03
.meas ac hr_b1_s2g1_1 FIND vr(hp_b1_s2g1_1) AT=1.000000e+03
.meas ac hi_b1_s2g1_1 FIND vi(hp_b1_s2g1_1) AT=1.000000e+03
.meas ac hr_st_s2g1_2 FIND vr(hp_st_s2g1_2) AT=1.000000e+03
.meas ac hi_st_s2g1_2 FIND vi(hp_st_s2g1_2) AT=1.000000e+03
.meas ac hr_b0_s2g1_2 FIND vr(hp_b0_s2g1_2) AT=1.000000e+03
.meas ac hi_b0_s2g1_2 FIND vi(hp_b0_s2g1_2) AT=1.000000e+03
.meas ac hr_b1_s2g1_2 FIND vr(hp_b1_s2g1_2) AT=1.000000e+03
.meas ac hi_b1_s2g1_2 FIND vi(hp_b1_s2g1_2) AT=1.000000e+03
.meas ac hr_st_s2g1_3 FIND vr(hp_st_s2g1_3) AT=1.000000e+03
.meas ac hi_st_s2g1_3 FIND vi(hp_st_s2g1_3) AT=1.000000e+03
.meas ac hr_b0_s2g1_3 FIND vr(hp_b0_s2g1_3) AT=1.000000e+03
.meas ac hi_b0_s2g1_3 FIND vi(hp_b0_s2g1_3) AT=1.000000e+03
.meas ac hr_b1_s2g1_3 FIND vr(hp_b1_s2g1_3) AT=1.000000e+03
.meas ac hi_b1_s2g1_3 FIND vi(hp_b1_s2g1_3) AT=1.000000e+03
.meas ac hr_st_s2g1_4 FIND vr(hp_st_s2g1_4) AT=1.000000e+03
.meas ac hi_st_s2g1_4 FIND vi(hp_st_s2g1_4) AT=1.000000e+03
.meas ac hr_b0_s2g1_4 FIND vr(hp_b0_s2g1_4) AT=1.000000e+03
.meas ac hi_b0_s2g1_4 FIND vi(hp_b0_s2g1_4) AT=1.000000e+03
.meas ac hr_b1_s2g1_4 FIND vr(hp_b1_s2g1_4) AT=1.000000e+03
.meas ac hi_b1_s2g1_4 FIND vi(hp_b1_s2g1_4) AT=1.000000e+03
.meas ac hr_st_s2g1_5 FIND vr(hp_st_s2g1_5) AT=1.000000e+03
.meas ac hi_st_s2g1_5 FIND vi(hp_st_s2g1_5) AT=1.000000e+03
.meas ac hr_b0_s2g1_5 FIND vr(hp_b0_s2g1_5) AT=1.000000e+03
.meas ac hi_b0_s2g1_5 FIND vi(hp_b0_s2g1_5) AT=1.000000e+03
.meas ac hr_b1_s2g1_5 FIND vr(hp_b1_s2g1_5) AT=1.000000e+03
.meas ac hi_b1_s2g1_5 FIND vi(hp_b1_s2g1_5) AT=1.000000e+03
.meas ac hr_st_s2g2_1 FIND vr(hp_st_s2g2_1) AT=1.000000e+03
.meas ac hi_st_s2g2_1 FIND vi(hp_st_s2g2_1) AT=1.000000e+03
.meas ac hr_b0_s2g2_1 FIND vr(hp_b0_s2g2_1) AT=1.000000e+03
.meas ac hi_b0_s2g2_1 FIND vi(hp_b0_s2g2_1) AT=1.000000e+03
.meas ac hr_b1_s2g2_1 FIND vr(hp_b1_s2g2_1) AT=1.000000e+03
.meas ac hi_b1_s2g2_1 FIND vi(hp_b1_s2g2_1) AT=1.000000e+03
.meas ac hr_st_s2g2_2 FIND vr(hp_st_s2g2_2) AT=1.000000e+03
.meas ac hi_st_s2g2_2 FIND vi(hp_st_s2g2_2) AT=1.000000e+03
.meas ac hr_b0_s2g2_2 FIND vr(hp_b0_s2g2_2) AT=1.000000e+03
.meas ac hi_b0_s2g2_2 FIND vi(hp_b0_s2g2_2) AT=1.000000e+03
.meas ac hr_b1_s2g2_2 FIND vr(hp_b1_s2g2_2) AT=1.000000e+03
.meas ac hi_b1_s2g2_2 FIND vi(hp_b1_s2g2_2) AT=1.000000e+03
.meas ac hr_st_s2g2_3 FIND vr(hp_st_s2g2_3) AT=1.000000e+03
.meas ac hi_st_s2g2_3 FIND vi(hp_st_s2g2_3) AT=1.000000e+03
.meas ac hr_b0_s2g2_3 FIND vr(hp_b0_s2g2_3) AT=1.000000e+03
.meas ac hi_b0_s2g2_3 FIND vi(hp_b0_s2g2_3) AT=1.000000e+03
.meas ac hr_b1_s2g2_3 FIND vr(hp_b1_s2g2_3) AT=1.000000e+03
.meas ac hi_b1_s2g2_3 FIND vi(hp_b1_s2g2_3) AT=1.000000e+03
.meas ac hr_st_s2g2_4 FIND vr(hp_st_s2g2_4) AT=1.000000e+03
.meas ac hi_st_s2g2_4 FIND vi(hp_st_s2g2_4) AT=1.000000e+03
.meas ac hr_b0_s2g2_4 FIND vr(hp_b0_s2g2_4) AT=1.000000e+03
.meas ac hi_b0_s2g2_4 FIND vi(hp_b0_s2g2_4) AT=1.000000e+03
.meas ac hr_b1_s2g2_4 FIND vr(hp_b1_s2g2_4) AT=1.000000e+03
.meas ac hi_b1_s2g2_4 FIND vi(hp_b1_s2g2_4) AT=1.000000e+03
.meas ac hr_st_s2g2_5 FIND vr(hp_st_s2g2_5) AT=1.000000e+03
.meas ac hi_st_s2g2_5 FIND vi(hp_st_s2g2_5) AT=1.000000e+03
.meas ac hr_b0_s2g2_5 FIND vr(hp_b0_s2g2_5) AT=1.000000e+03
.meas ac hi_b0_s2g2_5 FIND vi(hp_b0_s2g2_5) AT=1.000000e+03
.meas ac hr_b1_s2g2_5 FIND vr(hp_b1_s2g2_5) AT=1.000000e+03
.meas ac hi_b1_s2g2_5 FIND vi(hp_b1_s2g2_5) AT=1.000000e+03
.control
save all
ac lin 3 5.000000e+02 1.500000e+03
quit
.endc
.end
