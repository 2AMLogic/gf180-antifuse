* gf180-antifuse sim/cell-breakdown-model -- Candidate 2 capacitor bench (cap_ac)
* Generated by run_experiment.py; frozen here as evidence. See README.
* --- inlined from gf180mcuD/libs.tech/ngspice/design.ngspice (sha256 7e222f050318388f37543a64fbd0be55cc15e4b93f57501a09f7c159c4c9e561) ---
.param sw_stat_global=0
.param sw_stat_mismatch=0
.param mc_skew=3
.param res_mc_skew=3
.param cap_mc_skew=3
.param fnoicor=0
* --- end inline ---
.lib /home/ubuntu/.ciel/gf180mcuD/libs.tech/ngspice/smbb000149.ngspice typical
.options gmin=1.000000e-13
.include ../../../../../design/breakdown/cell_candidates_bd.spice

VBL BL 0 DC 0
VWL WL 0 DC 5.000000e+00
VVB VB 0 DC 0.000000e+00
VPL1 PL1 0 DC 6.000000e+00 AC 1
VPL2 PL2 0 DC 3.000000e+00 AC 1
VPL3 PL3 0 DC -0.000000e+00 AC 1
VPL4 PL4 0 DC -3.000000e+00 AC 1
VPL5 PL5 0 DC -6.000000e+00 AC 1
VM_st_s1g1_1 PL1 P_st_s1g1_1 0
X_st_s1g1_1 BL WL P_st_s1g1_1 VB cell_candidate2 wcap=1.000000e-06 lcap=1.000000e-06 wacc=2.500000e-05 lacc=6.000000e-07
H_st_s1g1_1 HP_st_s1g1_1 0 VM_st_s1g1_1 1
VM_b0_s1g1_1 PL1 P_b0_s1g1_1 0
X_b0_s1g1_1 BL WL P_b0_s1g1_1 VB cell_candidate2_bd wcap=1.000000e-06 lcap=1.000000e-06 wacc=2.500000e-05 lacc=6.000000e-07 bden=0
H_b0_s1g1_1 HP_b0_s1g1_1 0 VM_b0_s1g1_1 1
VM_b1_s1g1_1 PL1 P_b1_s1g1_1 0
X_b1_s1g1_1 BL WL P_b1_s1g1_1 VB cell_candidate2_bd wcap=1.000000e-06 lcap=1.000000e-06 wacc=2.500000e-05 lacc=6.000000e-07 bden=1 prog=0 dyn=0
H_b1_s1g1_1 HP_b1_s1g1_1 0 VM_b1_s1g1_1 1
VM_st_s1g1_2 PL2 P_st_s1g1_2 0
X_st_s1g1_2 BL WL P_st_s1g1_2 VB cell_candidate2 wcap=1.000000e-06 lcap=1.000000e-06 wacc=2.500000e-05 lacc=6.000000e-07
H_st_s1g1_2 HP_st_s1g1_2 0 VM_st_s1g1_2 1
VM_b0_s1g1_2 PL2 P_b0_s1g1_2 0
X_b0_s1g1_2 BL WL P_b0_s1g1_2 VB cell_candidate2_bd wcap=1.000000e-06 lcap=1.000000e-06 wacc=2.500000e-05 lacc=6.000000e-07 bden=0
H_b0_s1g1_2 HP_b0_s1g1_2 0 VM_b0_s1g1_2 1
VM_b1_s1g1_2 PL2 P_b1_s1g1_2 0
X_b1_s1g1_2 BL WL P_b1_s1g1_2 VB cell_candidate2_bd wcap=1.000000e-06 lcap=1.000000e-06 wacc=2.500000e-05 lacc=6.000000e-07 bden=1 prog=0 dyn=0
H_b1_s1g1_2 HP_b1_s1g1_2 0 VM_b1_s1g1_2 1
VM_st_s1g1_3 PL3 P_st_s1g1_3 0
X_st_s1g1_3 BL WL P_st_s1g1_3 VB cell_candidate2 wcap=1.000000e-06 lcap=1.000000e-06 wacc=2.500000e-05 lacc=6.000000e-07
H_st_s1g1_3 HP_st_s1g1_3 0 VM_st_s1g1_3 1
VM_b0_s1g1_3 PL3 P_b0_s1g1_3 0
X_b0_s1g1_3 BL WL P_b0_s1g1_3 VB cell_candidate2_bd wcap=1.000000e-06 lcap=1.000000e-06 wacc=2.500000e-05 lacc=6.000000e-07 bden=0
H_b0_s1g1_3 HP_b0_s1g1_3 0 VM_b0_s1g1_3 1
VM_b1_s1g1_3 PL3 P_b1_s1g1_3 0
X_b1_s1g1_3 BL WL P_b1_s1g1_3 VB cell_candidate2_bd wcap=1.000000e-06 lcap=1.000000e-06 wacc=2.500000e-05 lacc=6.000000e-07 bden=1 prog=0 dyn=0
H_b1_s1g1_3 HP_b1_s1g1_3 0 VM_b1_s1g1_3 1
VM_st_s1g1_4 PL4 P_st_s1g1_4 0
X_st_s1g1_4 BL WL P_st_s1g1_4 VB cell_candidate2 wcap=1.000000e-06 lcap=1.000000e-06 wacc=2.500000e-05 lacc=6.000000e-07
H_st_s1g1_4 HP_st_s1g1_4 0 VM_st_s1g1_4 1
VM_b0_s1g1_4 PL4 P_b0_s1g1_4 0
X_b0_s1g1_4 BL WL P_b0_s1g1_4 VB cell_candidate2_bd wcap=1.000000e-06 lcap=1.000000e-06 wacc=2.500000e-05 lacc=6.000000e-07 bden=0
H_b0_s1g1_4 HP_b0_s1g1_4 0 VM_b0_s1g1_4 1
VM_b1_s1g1_4 PL4 P_b1_s1g1_4 0
X_b1_s1g1_4 BL WL P_b1_s1g1_4 VB cell_candidate2_bd wcap=1.000000e-06 lcap=1.000000e-06 wacc=2.500000e-05 lacc=6.000000e-07 bden=1 prog=0 dyn=0
H_b1_s1g1_4 HP_b1_s1g1_4 0 VM_b1_s1g1_4 1
VM_st_s1g1_5 PL5 P_st_s1g1_5 0
X_st_s1g1_5 BL WL P_st_s1g1_5 VB cell_candidate2 wcap=1.000000e-06 lcap=1.000000e-06 wacc=2.500000e-05 lacc=6.000000e-07
H_st_s1g1_5 HP_st_s1g1_5 0 VM_st_s1g1_5 1
VM_b0_s1g1_5 PL5 P_b0_s1g1_5 0
X_b0_s1g1_5 BL WL P_b0_s1g1_5 VB cell_candidate2_bd wcap=1.000000e-06 lcap=1.000000e-06 wacc=2.500000e-05 lacc=6.000000e-07 bden=0
H_b0_s1g1_5 HP_b0_s1g1_5 0 VM_b0_s1g1_5 1
VM_b1_s1g1_5 PL5 P_b1_s1g1_5 0
X_b1_s1g1_5 BL WL P_b1_s1g1_5 VB cell_candidate2_bd wcap=1.000000e-06 lcap=1.000000e-06 wacc=2.500000e-05 lacc=6.000000e-07 bden=1 prog=0 dyn=0
H_b1_s1g1_5 HP_b1_s1g1_5 0 VM_b1_s1g1_5 1
VM_st_s1g2_1 PL1 P_st_s1g2_1 0
X_st_s1g2_1 BL WL P_st_s1g2_1 VB cell_candidate2 wcap=2.000000e-06 lcap=1.000000e-06 wacc=2.500000e-05 lacc=6.000000e-07
H_st_s1g2_1 HP_st_s1g2_1 0 VM_st_s1g2_1 1
VM_b0_s1g2_1 PL1 P_b0_s1g2_1 0
X_b0_s1g2_1 BL WL P_b0_s1g2_1 VB cell_candidate2_bd wcap=2.000000e-06 lcap=1.000000e-06 wacc=2.500000e-05 lacc=6.000000e-07 bden=0
H_b0_s1g2_1 HP_b0_s1g2_1 0 VM_b0_s1g2_1 1
VM_b1_s1g2_1 PL1 P_b1_s1g2_1 0
X_b1_s1g2_1 BL WL P_b1_s1g2_1 VB cell_candidate2_bd wcap=2.000000e-06 lcap=1.000000e-06 wacc=2.500000e-05 lacc=6.000000e-07 bden=1 prog=0 dyn=0
H_b1_s1g2_1 HP_b1_s1g2_1 0 VM_b1_s1g2_1 1
VM_st_s1g2_2 PL2 P_st_s1g2_2 0
X_st_s1g2_2 BL WL P_st_s1g2_2 VB cell_candidate2 wcap=2.000000e-06 lcap=1.000000e-06 wacc=2.500000e-05 lacc=6.000000e-07
H_st_s1g2_2 HP_st_s1g2_2 0 VM_st_s1g2_2 1
VM_b0_s1g2_2 PL2 P_b0_s1g2_2 0
X_b0_s1g2_2 BL WL P_b0_s1g2_2 VB cell_candidate2_bd wcap=2.000000e-06 lcap=1.000000e-06 wacc=2.500000e-05 lacc=6.000000e-07 bden=0
H_b0_s1g2_2 HP_b0_s1g2_2 0 VM_b0_s1g2_2 1
VM_b1_s1g2_2 PL2 P_b1_s1g2_2 0
X_b1_s1g2_2 BL WL P_b1_s1g2_2 VB cell_candidate2_bd wcap=2.000000e-06 lcap=1.000000e-06 wacc=2.500000e-05 lacc=6.000000e-07 bden=1 prog=0 dyn=0
H_b1_s1g2_2 HP_b1_s1g2_2 0 VM_b1_s1g2_2 1
VM_st_s1g2_3 PL3 P_st_s1g2_3 0
X_st_s1g2_3 BL WL P_st_s1g2_3 VB cell_candidate2 wcap=2.000000e-06 lcap=1.000000e-06 wacc=2.500000e-05 lacc=6.000000e-07
H_st_s1g2_3 HP_st_s1g2_3 0 VM_st_s1g2_3 1
VM_b0_s1g2_3 PL3 P_b0_s1g2_3 0
X_b0_s1g2_3 BL WL P_b0_s1g2_3 VB cell_candidate2_bd wcap=2.000000e-06 lcap=1.000000e-06 wacc=2.500000e-05 lacc=6.000000e-07 bden=0
H_b0_s1g2_3 HP_b0_s1g2_3 0 VM_b0_s1g2_3 1
VM_b1_s1g2_3 PL3 P_b1_s1g2_3 0
X_b1_s1g2_3 BL WL P_b1_s1g2_3 VB cell_candidate2_bd wcap=2.000000e-06 lcap=1.000000e-06 wacc=2.500000e-05 lacc=6.000000e-07 bden=1 prog=0 dyn=0
H_b1_s1g2_3 HP_b1_s1g2_3 0 VM_b1_s1g2_3 1
VM_st_s1g2_4 PL4 P_st_s1g2_4 0
X_st_s1g2_4 BL WL P_st_s1g2_4 VB cell_candidate2 wcap=2.000000e-06 lcap=1.000000e-06 wacc=2.500000e-05 lacc=6.000000e-07
H_st_s1g2_4 HP_st_s1g2_4 0 VM_st_s1g2_4 1
VM_b0_s1g2_4 PL4 P_b0_s1g2_4 0
X_b0_s1g2_4 BL WL P_b0_s1g2_4 VB cell_candidate2_bd wcap=2.000000e-06 lcap=1.000000e-06 wacc=2.500000e-05 lacc=6.000000e-07 bden=0
H_b0_s1g2_4 HP_b0_s1g2_4 0 VM_b0_s1g2_4 1
VM_b1_s1g2_4 PL4 P_b1_s1g2_4 0
X_b1_s1g2_4 BL WL P_b1_s1g2_4 VB cell_candidate2_bd wcap=2.000000e-06 lcap=1.000000e-06 wacc=2.500000e-05 lacc=6.000000e-07 bden=1 prog=0 dyn=0
H_b1_s1g2_4 HP_b1_s1g2_4 0 VM_b1_s1g2_4 1
VM_st_s1g2_5 PL5 P_st_s1g2_5 0
X_st_s1g2_5 BL WL P_st_s1g2_5 VB cell_candidate2 wcap=2.000000e-06 lcap=1.000000e-06 wacc=2.500000e-05 lacc=6.000000e-07
H_st_s1g2_5 HP_st_s1g2_5 0 VM_st_s1g2_5 1
VM_b0_s1g2_5 PL5 P_b0_s1g2_5 0
X_b0_s1g2_5 BL WL P_b0_s1g2_5 VB cell_candidate2_bd wcap=2.000000e-06 lcap=1.000000e-06 wacc=2.500000e-05 lacc=6.000000e-07 bden=0
H_b0_s1g2_5 HP_b0_s1g2_5 0 VM_b0_s1g2_5 1
VM_b1_s1g2_5 PL5 P_b1_s1g2_5 0
X_b1_s1g2_5 BL WL P_b1_s1g2_5 VB cell_candidate2_bd wcap=2.000000e-06 lcap=1.000000e-06 wacc=2.500000e-05 lacc=6.000000e-07 bden=1 prog=0 dyn=0
H_b1_s1g2_5 HP_b1_s1g2_5 0 VM_b1_s1g2_5 1
VM_st_s2g1_1 PL1 P_st_s2g1_1 0
X_st_s2g1_1 BL WL P_st_s2g1_1 VB cell_candidate2 wcap=1.000000e-06 lcap=1.000000e-06 wacc=5.000000e-05 lacc=6.000000e-07
H_st_s2g1_1 HP_st_s2g1_1 0 VM_st_s2g1_1 1
VM_b0_s2g1_1 PL1 P_b0_s2g1_1 0
X_b0_s2g1_1 BL WL P_b0_s2g1_1 VB cell_candidate2_bd wcap=1.000000e-06 lcap=1.000000e-06 wacc=5.000000e-05 lacc=6.000000e-07 bden=0
H_b0_s2g1_1 HP_b0_s2g1_1 0 VM_b0_s2g1_1 1
VM_b1_s2g1_1 PL1 P_b1_s2g1_1 0
X_b1_s2g1_1 BL WL P_b1_s2g1_1 VB cell_candidate2_bd wcap=1.000000e-06 lcap=1.000000e-06 wacc=5.000000e-05 lacc=6.000000e-07 bden=1 prog=0 dyn=0
H_b1_s2g1_1 HP_b1_s2g1_1 0 VM_b1_s2g1_1 1
VM_st_s2g1_2 PL2 P_st_s2g1_2 0
X_st_s2g1_2 BL WL P_st_s2g1_2 VB cell_candidate2 wcap=1.000000e-06 lcap=1.000000e-06 wacc=5.000000e-05 lacc=6.000000e-07
H_st_s2g1_2 HP_st_s2g1_2 0 VM_st_s2g1_2 1
VM_b0_s2g1_2 PL2 P_b0_s2g1_2 0
X_b0_s2g1_2 BL WL P_b0_s2g1_2 VB cell_candidate2_bd wcap=1.000000e-06 lcap=1.000000e-06 wacc=5.000000e-05 lacc=6.000000e-07 bden=0
H_b0_s2g1_2 HP_b0_s2g1_2 0 VM_b0_s2g1_2 1
VM_b1_s2g1_2 PL2 P_b1_s2g1_2 0
X_b1_s2g1_2 BL WL P_b1_s2g1_2 VB cell_candidate2_bd wcap=1.000000e-06 lcap=1.000000e-06 wacc=5.000000e-05 lacc=6.000000e-07 bden=1 prog=0 dyn=0
H_b1_s2g1_2 HP_b1_s2g1_2 0 VM_b1_s2g1_2 1
VM_st_s2g1_3 PL3 P_st_s2g1_3 0
X_st_s2g1_3 BL WL P_st_s2g1_3 VB cell_candidate2 wcap=1.000000e-06 lcap=1.000000e-06 wacc=5.000000e-05 lacc=6.000000e-07
H_st_s2g1_3 HP_st_s2g1_3 0 VM_st_s2g1_3 1
VM_b0_s2g1_3 PL3 P_b0_s2g1_3 0
X_b0_s2g1_3 BL WL P_b0_s2g1_3 VB cell_candidate2_bd wcap=1.000000e-06 lcap=1.000000e-06 wacc=5.000000e-05 lacc=6.000000e-07 bden=0
H_b0_s2g1_3 HP_b0_s2g1_3 0 VM_b0_s2g1_3 1
VM_b1_s2g1_3 PL3 P_b1_s2g1_3 0
X_b1_s2g1_3 BL WL P_b1_s2g1_3 VB cell_candidate2_bd wcap=1.000000e-06 lcap=1.000000e-06 wacc=5.000000e-05 lacc=6.000000e-07 bden=1 prog=0 dyn=0
H_b1_s2g1_3 HP_b1_s2g1_3 0 VM_b1_s2g1_3 1
VM_st_s2g1_4 PL4 P_st_s2g1_4 0
X_st_s2g1_4 BL WL P_st_s2g1_4 VB cell_candidate2 wcap=1.000000e-06 lcap=1.000000e-06 wacc=5.000000e-05 lacc=6.000000e-07
H_st_s2g1_4 HP_st_s2g1_4 0 VM_st_s2g1_4 1
VM_b0_s2g1_4 PL4 P_b0_s2g1_4 0
X_b0_s2g1_4 BL WL P_b0_s2g1_4 VB cell_candidate2_bd wcap=1.000000e-06 lcap=1.000000e-06 wacc=5.000000e-05 lacc=6.000000e-07 bden=0
H_b0_s2g1_4 HP_b0_s2g1_4 0 VM_b0_s2g1_4 1
VM_b1_s2g1_4 PL4 P_b1_s2g1_4 0
X_b1_s2g1_4 BL WL P_b1_s2g1_4 VB cell_candidate2_bd wcap=1.000000e-06 lcap=1.000000e-06 wacc=5.000000e-05 lacc=6.000000e-07 bden=1 prog=0 dyn=0
H_b1_s2g1_4 HP_b1_s2g1_4 0 VM_b1_s2g1_4 1
VM_st_s2g1_5 PL5 P_st_s2g1_5 0
X_st_s2g1_5 BL WL P_st_s2g1_5 VB cell_candidate2 wcap=1.000000e-06 lcap=1.000000e-06 wacc=5.000000e-05 lacc=6.000000e-07
H_st_s2g1_5 HP_st_s2g1_5 0 VM_st_s2g1_5 1
VM_b0_s2g1_5 PL5 P_b0_s2g1_5 0
X_b0_s2g1_5 BL WL P_b0_s2g1_5 VB cell_candidate2_bd wcap=1.000000e-06 lcap=1.000000e-06 wacc=5.000000e-05 lacc=6.000000e-07 bden=0
H_b0_s2g1_5 HP_b0_s2g1_5 0 VM_b0_s2g1_5 1
VM_b1_s2g1_5 PL5 P_b1_s2g1_5 0
X_b1_s2g1_5 BL WL P_b1_s2g1_5 VB cell_candidate2_bd wcap=1.000000e-06 lcap=1.000000e-06 wacc=5.000000e-05 lacc=6.000000e-07 bden=1 prog=0 dyn=0
H_b1_s2g1_5 HP_b1_s2g1_5 0 VM_b1_s2g1_5 1
VM_st_s2g2_1 PL1 P_st_s2g2_1 0
X_st_s2g2_1 BL WL P_st_s2g2_1 VB cell_candidate2 wcap=2.000000e-06 lcap=1.000000e-06 wacc=5.000000e-05 lacc=6.000000e-07
H_st_s2g2_1 HP_st_s2g2_1 0 VM_st_s2g2_1 1
VM_b0_s2g2_1 PL1 P_b0_s2g2_1 0
X_b0_s2g2_1 BL WL P_b0_s2g2_1 VB cell_candidate2_bd wcap=2.000000e-06 lcap=1.000000e-06 wacc=5.000000e-05 lacc=6.000000e-07 bden=0
H_b0_s2g2_1 HP_b0_s2g2_1 0 VM_b0_s2g2_1 1
VM_b1_s2g2_1 PL1 P_b1_s2g2_1 0
X_b1_s2g2_1 BL WL P_b1_s2g2_1 VB cell_candidate2_bd wcap=2.000000e-06 lcap=1.000000e-06 wacc=5.000000e-05 lacc=6.000000e-07 bden=1 prog=0 dyn=0
H_b1_s2g2_1 HP_b1_s2g2_1 0 VM_b1_s2g2_1 1
VM_st_s2g2_2 PL2 P_st_s2g2_2 0
X_st_s2g2_2 BL WL P_st_s2g2_2 VB cell_candidate2 wcap=2.000000e-06 lcap=1.000000e-06 wacc=5.000000e-05 lacc=6.000000e-07
H_st_s2g2_2 HP_st_s2g2_2 0 VM_st_s2g2_2 1
VM_b0_s2g2_2 PL2 P_b0_s2g2_2 0
X_b0_s2g2_2 BL WL P_b0_s2g2_2 VB cell_candidate2_bd wcap=2.000000e-06 lcap=1.000000e-06 wacc=5.000000e-05 lacc=6.000000e-07 bden=0
H_b0_s2g2_2 HP_b0_s2g2_2 0 VM_b0_s2g2_2 1
VM_b1_s2g2_2 PL2 P_b1_s2g2_2 0
X_b1_s2g2_2 BL WL P_b1_s2g2_2 VB cell_candidate2_bd wcap=2.000000e-06 lcap=1.000000e-06 wacc=5.000000e-05 lacc=6.000000e-07 bden=1 prog=0 dyn=0
H_b1_s2g2_2 HP_b1_s2g2_2 0 VM_b1_s2g2_2 1
VM_st_s2g2_3 PL3 P_st_s2g2_3 0
X_st_s2g2_3 BL WL P_st_s2g2_3 VB cell_candidate2 wcap=2.000000e-06 lcap=1.000000e-06 wacc=5.000000e-05 lacc=6.000000e-07
H_st_s2g2_3 HP_st_s2g2_3 0 VM_st_s2g2_3 1
VM_b0_s2g2_3 PL3 P_b0_s2g2_3 0
X_b0_s2g2_3 BL WL P_b0_s2g2_3 VB cell_candidate2_bd wcap=2.000000e-06 lcap=1.000000e-06 wacc=5.000000e-05 lacc=6.000000e-07 bden=0
H_b0_s2g2_3 HP_b0_s2g2_3 0 VM_b0_s2g2_3 1
VM_b1_s2g2_3 PL3 P_b1_s2g2_3 0
X_b1_s2g2_3 BL WL P_b1_s2g2_3 VB cell_candidate2_bd wcap=2.000000e-06 lcap=1.000000e-06 wacc=5.000000e-05 lacc=6.000000e-07 bden=1 prog=0 dyn=0
H_b1_s2g2_3 HP_b1_s2g2_3 0 VM_b1_s2g2_3 1
VM_st_s2g2_4 PL4 P_st_s2g2_4 0
X_st_s2g2_4 BL WL P_st_s2g2_4 VB cell_candidate2 wcap=2.000000e-06 lcap=1.000000e-06 wacc=5.000000e-05 lacc=6.000000e-07
H_st_s2g2_4 HP_st_s2g2_4 0 VM_st_s2g2_4 1
VM_b0_s2g2_4 PL4 P_b0_s2g2_4 0
X_b0_s2g2_4 BL WL P_b0_s2g2_4 VB cell_candidate2_bd wcap=2.000000e-06 lcap=1.000000e-06 wacc=5.000000e-05 lacc=6.000000e-07 bden=0
H_b0_s2g2_4 HP_b0_s2g2_4 0 VM_b0_s2g2_4 1
VM_b1_s2g2_4 PL4 P_b1_s2g2_4 0
X_b1_s2g2_4 BL WL P_b1_s2g2_4 VB cell_candidate2_bd wcap=2.000000e-06 lcap=1.000000e-06 wacc=5.000000e-05 lacc=6.000000e-07 bden=1 prog=0 dyn=0
H_b1_s2g2_4 HP_b1_s2g2_4 0 VM_b1_s2g2_4 1
VM_st_s2g2_5 PL5 P_st_s2g2_5 0
X_st_s2g2_5 BL WL P_st_s2g2_5 VB cell_candidate2 wcap=2.000000e-06 lcap=1.000000e-06 wacc=5.000000e-05 lacc=6.000000e-07
H_st_s2g2_5 HP_st_s2g2_5 0 VM_st_s2g2_5 1
VM_b0_s2g2_5 PL5 P_b0_s2g2_5 0
X_b0_s2g2_5 BL WL P_b0_s2g2_5 VB cell_candidate2_bd wcap=2.000000e-06 lcap=1.000000e-06 wacc=5.000000e-05 lacc=6.000000e-07 bden=0
H_b0_s2g2_5 HP_b0_s2g2_5 0 VM_b0_s2g2_5 1
VM_b1_s2g2_5 PL5 P_b1_s2g2_5 0
X_b1_s2g2_5 BL WL P_b1_s2g2_5 VB cell_candidate2_bd wcap=2.000000e-06 lcap=1.000000e-06 wacc=5.000000e-05 lacc=6.000000e-07 bden=1 prog=0 dyn=0
H_b1_s2g2_5 HP_b1_s2g2_5 0 VM_b1_s2g2_5 1
