* gf180-antifuse sim/cell-breakdown-model -- Candidate 3 read-bias bench (bias_op)
* Generated by run_experiment.py; frozen here as evidence. See README.
* --- inlined from gf180mcuD/libs.tech/ngspice/design.ngspice (sha256 7e222f050318388f37543a64fbd0be55cc15e4b93f57501a09f7c159c4c9e561) ---
.param sw_stat_global=0
.param sw_stat_mismatch=0
.param mc_skew=3
.param res_mc_skew=3
.param cap_mc_skew=3
.param fnoicor=0
* --- end inline ---
.options gmin=1.000000e-13
.include ../../../../../design/breakdown/cell_candidates_bd.spice
* V_bd sensitivity point (issue #130): per-candidate override of the shared bd_ebd
.param bd_ebd = 1.11392405e+09

VBL BL 0 DC 1.000000e+00
VPL PL 0 DC 0
VDMY DMY 0 DC 0
VWLLO WLLO 0 DC 3.000000e+00
VWLMID WLMID 0 DC 3.300000e+00
VWLHI WLHI 0 DC 3.600000e+00
EBL_s0_placeholder BLS_s0_placeholder 0 BL 0 1.000000e+00
VVB_s0_placeholder VB_s0_placeholder 0 DC 3.300000e+00
VWLON_s0_placeholder WLON_s0_placeholder 0 DC 0.000000e+00
VM_off_s0_placeholder_s1g1_lo BLS_s0_placeholder B_off_s0_placeholder_s1g1_lo 0
X_off_s0_placeholder_s1g1_lo B_off_s0_placeholder_s1g1_lo WLLO PL VB_s0_placeholder cell_candidate3_bd wcap=1.000000e-06 lcap=1.000000e-06 wacc=3.000000e-07 lacc=5.500000e-07 bden=1 prog=0 dyn=0
VM_off_s0_placeholder_s1g1_mid BLS_s0_placeholder B_off_s0_placeholder_s1g1_mid 0
X_off_s0_placeholder_s1g1_mid B_off_s0_placeholder_s1g1_mid WLMID PL VB_s0_placeholder cell_candidate3_bd wcap=1.000000e-06 lcap=1.000000e-06 wacc=3.000000e-07 lacc=5.500000e-07 bden=1 prog=0 dyn=0
VM_off_s0_placeholder_s1g1_hi BLS_s0_placeholder B_off_s0_placeholder_s1g1_hi 0
X_off_s0_placeholder_s1g1_hi B_off_s0_placeholder_s1g1_hi WLHI PL VB_s0_placeholder cell_candidate3_bd wcap=1.000000e-06 lcap=1.000000e-06 wacc=3.000000e-07 lacc=5.500000e-07 bden=1 prog=0 dyn=0
VM_offp_s0_placeholder_s1g1_lo BLS_s0_placeholder B_offp_s0_placeholder_s1g1_lo 0
X_offp_s0_placeholder_s1g1_lo B_offp_s0_placeholder_s1g1_lo WLLO PL VB_s0_placeholder cell_candidate3_bd wcap=1.000000e-06 lcap=1.000000e-06 wacc=3.000000e-07 lacc=5.500000e-07 bden=1 prog=1 dyn=0 zrf=0
VM_offp_s0_placeholder_s1g1_mid BLS_s0_placeholder B_offp_s0_placeholder_s1g1_mid 0
X_offp_s0_placeholder_s1g1_mid B_offp_s0_placeholder_s1g1_mid WLMID PL VB_s0_placeholder cell_candidate3_bd wcap=1.000000e-06 lcap=1.000000e-06 wacc=3.000000e-07 lacc=5.500000e-07 bden=1 prog=1 dyn=0 zrf=0
VM_offp_s0_placeholder_s1g1_hi BLS_s0_placeholder B_offp_s0_placeholder_s1g1_hi 0
X_offp_s0_placeholder_s1g1_hi B_offp_s0_placeholder_s1g1_hi WLHI PL VB_s0_placeholder cell_candidate3_bd wcap=1.000000e-06 lcap=1.000000e-06 wacc=3.000000e-07 lacc=5.500000e-07 bden=1 prog=1 dyn=0 zrf=0
VM_un_s0_placeholder_s1g1 BLS_s0_placeholder B_un_s0_placeholder_s1g1 0
X_un_s0_placeholder_s1g1 B_un_s0_placeholder_s1g1 WLON_s0_placeholder PL VB_s0_placeholder cell_candidate3_bd wcap=1.000000e-06 lcap=1.000000e-06 wacc=3.000000e-07 lacc=5.500000e-07 bden=1 prog=0 dyn=0
VM_pm_s0_placeholder_s1g1 BLS_s0_placeholder B_pm_s0_placeholder_s1g1 0
X_pm_s0_placeholder_s1g1 B_pm_s0_placeholder_s1g1 WLON_s0_placeholder PL VB_s0_placeholder cell_candidate3_bd wcap=1.000000e-06 lcap=1.000000e-06 wacc=3.000000e-07 lacc=5.500000e-07 bden=1 prog=1 dyn=0 zrf=0
VM_pw_s0_placeholder_s1g1 BLS_s0_placeholder B_pw_s0_placeholder_s1g1 0
X_pw_s0_placeholder_s1g1 B_pw_s0_placeholder_s1g1 WLON_s0_placeholder PL VB_s0_placeholder cell_candidate3_bd wcap=1.000000e-06 lcap=1.000000e-06 wacc=3.000000e-07 lacc=5.500000e-07 bden=1 prog=1 dyn=0 zrf={bd_zrf_wc}
VM_off_s0_placeholder_s1g2_lo BLS_s0_placeholder B_off_s0_placeholder_s1g2_lo 0
X_off_s0_placeholder_s1g2_lo B_off_s0_placeholder_s1g2_lo WLLO PL VB_s0_placeholder cell_candidate3_bd wcap=2.000000e-06 lcap=1.000000e-06 wacc=3.000000e-07 lacc=5.500000e-07 bden=1 prog=0 dyn=0
VM_off_s0_placeholder_s1g2_mid BLS_s0_placeholder B_off_s0_placeholder_s1g2_mid 0
X_off_s0_placeholder_s1g2_mid B_off_s0_placeholder_s1g2_mid WLMID PL VB_s0_placeholder cell_candidate3_bd wcap=2.000000e-06 lcap=1.000000e-06 wacc=3.000000e-07 lacc=5.500000e-07 bden=1 prog=0 dyn=0
VM_off_s0_placeholder_s1g2_hi BLS_s0_placeholder B_off_s0_placeholder_s1g2_hi 0
X_off_s0_placeholder_s1g2_hi B_off_s0_placeholder_s1g2_hi WLHI PL VB_s0_placeholder cell_candidate3_bd wcap=2.000000e-06 lcap=1.000000e-06 wacc=3.000000e-07 lacc=5.500000e-07 bden=1 prog=0 dyn=0
VM_offp_s0_placeholder_s1g2_lo BLS_s0_placeholder B_offp_s0_placeholder_s1g2_lo 0
X_offp_s0_placeholder_s1g2_lo B_offp_s0_placeholder_s1g2_lo WLLO PL VB_s0_placeholder cell_candidate3_bd wcap=2.000000e-06 lcap=1.000000e-06 wacc=3.000000e-07 lacc=5.500000e-07 bden=1 prog=1 dyn=0 zrf=0
VM_offp_s0_placeholder_s1g2_mid BLS_s0_placeholder B_offp_s0_placeholder_s1g2_mid 0
X_offp_s0_placeholder_s1g2_mid B_offp_s0_placeholder_s1g2_mid WLMID PL VB_s0_placeholder cell_candidate3_bd wcap=2.000000e-06 lcap=1.000000e-06 wacc=3.000000e-07 lacc=5.500000e-07 bden=1 prog=1 dyn=0 zrf=0
VM_offp_s0_placeholder_s1g2_hi BLS_s0_placeholder B_offp_s0_placeholder_s1g2_hi 0
X_offp_s0_placeholder_s1g2_hi B_offp_s0_placeholder_s1g2_hi WLHI PL VB_s0_placeholder cell_candidate3_bd wcap=2.000000e-06 lcap=1.000000e-06 wacc=3.000000e-07 lacc=5.500000e-07 bden=1 prog=1 dyn=0 zrf=0
VM_un_s0_placeholder_s1g2 BLS_s0_placeholder B_un_s0_placeholder_s1g2 0
X_un_s0_placeholder_s1g2 B_un_s0_placeholder_s1g2 WLON_s0_placeholder PL VB_s0_placeholder cell_candidate3_bd wcap=2.000000e-06 lcap=1.000000e-06 wacc=3.000000e-07 lacc=5.500000e-07 bden=1 prog=0 dyn=0
VM_pm_s0_placeholder_s1g2 BLS_s0_placeholder B_pm_s0_placeholder_s1g2 0
X_pm_s0_placeholder_s1g2 B_pm_s0_placeholder_s1g2 WLON_s0_placeholder PL VB_s0_placeholder cell_candidate3_bd wcap=2.000000e-06 lcap=1.000000e-06 wacc=3.000000e-07 lacc=5.500000e-07 bden=1 prog=1 dyn=0 zrf=0
VM_pw_s0_placeholder_s1g2 BLS_s0_placeholder B_pw_s0_placeholder_s1g2 0
X_pw_s0_placeholder_s1g2 B_pw_s0_placeholder_s1g2 WLON_s0_placeholder PL VB_s0_placeholder cell_candidate3_bd wcap=2.000000e-06 lcap=1.000000e-06 wacc=3.000000e-07 lacc=5.500000e-07 bden=1 prog=1 dyn=0 zrf={bd_zrf_wc}
VM_off_s0_placeholder_s2g1_lo BLS_s0_placeholder B_off_s0_placeholder_s2g1_lo 0
X_off_s0_placeholder_s2g1_lo B_off_s0_placeholder_s2g1_lo WLLO PL VB_s0_placeholder cell_candidate3_bd wcap=1.000000e-06 lcap=1.000000e-06 wacc=6.000000e-07 lacc=5.500000e-07 bden=1 prog=0 dyn=0
VM_off_s0_placeholder_s2g1_mid BLS_s0_placeholder B_off_s0_placeholder_s2g1_mid 0
X_off_s0_placeholder_s2g1_mid B_off_s0_placeholder_s2g1_mid WLMID PL VB_s0_placeholder cell_candidate3_bd wcap=1.000000e-06 lcap=1.000000e-06 wacc=6.000000e-07 lacc=5.500000e-07 bden=1 prog=0 dyn=0
VM_off_s0_placeholder_s2g1_hi BLS_s0_placeholder B_off_s0_placeholder_s2g1_hi 0
X_off_s0_placeholder_s2g1_hi B_off_s0_placeholder_s2g1_hi WLHI PL VB_s0_placeholder cell_candidate3_bd wcap=1.000000e-06 lcap=1.000000e-06 wacc=6.000000e-07 lacc=5.500000e-07 bden=1 prog=0 dyn=0
VM_offp_s0_placeholder_s2g1_lo BLS_s0_placeholder B_offp_s0_placeholder_s2g1_lo 0
X_offp_s0_placeholder_s2g1_lo B_offp_s0_placeholder_s2g1_lo WLLO PL VB_s0_placeholder cell_candidate3_bd wcap=1.000000e-06 lcap=1.000000e-06 wacc=6.000000e-07 lacc=5.500000e-07 bden=1 prog=1 dyn=0 zrf=0
VM_offp_s0_placeholder_s2g1_mid BLS_s0_placeholder B_offp_s0_placeholder_s2g1_mid 0
X_offp_s0_placeholder_s2g1_mid B_offp_s0_placeholder_s2g1_mid WLMID PL VB_s0_placeholder cell_candidate3_bd wcap=1.000000e-06 lcap=1.000000e-06 wacc=6.000000e-07 lacc=5.500000e-07 bden=1 prog=1 dyn=0 zrf=0
VM_offp_s0_placeholder_s2g1_hi BLS_s0_placeholder B_offp_s0_placeholder_s2g1_hi 0
X_offp_s0_placeholder_s2g1_hi B_offp_s0_placeholder_s2g1_hi WLHI PL VB_s0_placeholder cell_candidate3_bd wcap=1.000000e-06 lcap=1.000000e-06 wacc=6.000000e-07 lacc=5.500000e-07 bden=1 prog=1 dyn=0 zrf=0
VM_un_s0_placeholder_s2g1 BLS_s0_placeholder B_un_s0_placeholder_s2g1 0
X_un_s0_placeholder_s2g1 B_un_s0_placeholder_s2g1 WLON_s0_placeholder PL VB_s0_placeholder cell_candidate3_bd wcap=1.000000e-06 lcap=1.000000e-06 wacc=6.000000e-07 lacc=5.500000e-07 bden=1 prog=0 dyn=0
VM_pm_s0_placeholder_s2g1 BLS_s0_placeholder B_pm_s0_placeholder_s2g1 0
X_pm_s0_placeholder_s2g1 B_pm_s0_placeholder_s2g1 WLON_s0_placeholder PL VB_s0_placeholder cell_candidate3_bd wcap=1.000000e-06 lcap=1.000000e-06 wacc=6.000000e-07 lacc=5.500000e-07 bden=1 prog=1 dyn=0 zrf=0
VM_pw_s0_placeholder_s2g1 BLS_s0_placeholder B_pw_s0_placeholder_s2g1 0
X_pw_s0_placeholder_s2g1 B_pw_s0_placeholder_s2g1 WLON_s0_placeholder PL VB_s0_placeholder cell_candidate3_bd wcap=1.000000e-06 lcap=1.000000e-06 wacc=6.000000e-07 lacc=5.500000e-07 bden=1 prog=1 dyn=0 zrf={bd_zrf_wc}
VM_off_s0_placeholder_s2g2_lo BLS_s0_placeholder B_off_s0_placeholder_s2g2_lo 0
X_off_s0_placeholder_s2g2_lo B_off_s0_placeholder_s2g2_lo WLLO PL VB_s0_placeholder cell_candidate3_bd wcap=2.000000e-06 lcap=1.000000e-06 wacc=6.000000e-07 lacc=5.500000e-07 bden=1 prog=0 dyn=0
VM_off_s0_placeholder_s2g2_mid BLS_s0_placeholder B_off_s0_placeholder_s2g2_mid 0
X_off_s0_placeholder_s2g2_mid B_off_s0_placeholder_s2g2_mid WLMID PL VB_s0_placeholder cell_candidate3_bd wcap=2.000000e-06 lcap=1.000000e-06 wacc=6.000000e-07 lacc=5.500000e-07 bden=1 prog=0 dyn=0
VM_off_s0_placeholder_s2g2_hi BLS_s0_placeholder B_off_s0_placeholder_s2g2_hi 0
X_off_s0_placeholder_s2g2_hi B_off_s0_placeholder_s2g2_hi WLHI PL VB_s0_placeholder cell_candidate3_bd wcap=2.000000e-06 lcap=1.000000e-06 wacc=6.000000e-07 lacc=5.500000e-07 bden=1 prog=0 dyn=0
VM_offp_s0_placeholder_s2g2_lo BLS_s0_placeholder B_offp_s0_placeholder_s2g2_lo 0
X_offp_s0_placeholder_s2g2_lo B_offp_s0_placeholder_s2g2_lo WLLO PL VB_s0_placeholder cell_candidate3_bd wcap=2.000000e-06 lcap=1.000000e-06 wacc=6.000000e-07 lacc=5.500000e-07 bden=1 prog=1 dyn=0 zrf=0
VM_offp_s0_placeholder_s2g2_mid BLS_s0_placeholder B_offp_s0_placeholder_s2g2_mid 0
X_offp_s0_placeholder_s2g2_mid B_offp_s0_placeholder_s2g2_mid WLMID PL VB_s0_placeholder cell_candidate3_bd wcap=2.000000e-06 lcap=1.000000e-06 wacc=6.000000e-07 lacc=5.500000e-07 bden=1 prog=1 dyn=0 zrf=0
VM_offp_s0_placeholder_s2g2_hi BLS_s0_placeholder B_offp_s0_placeholder_s2g2_hi 0
X_offp_s0_placeholder_s2g2_hi B_offp_s0_placeholder_s2g2_hi WLHI PL VB_s0_placeholder cell_candidate3_bd wcap=2.000000e-06 lcap=1.000000e-06 wacc=6.000000e-07 lacc=5.500000e-07 bden=1 prog=1 dyn=0 zrf=0
VM_un_s0_placeholder_s2g2 BLS_s0_placeholder B_un_s0_placeholder_s2g2 0
X_un_s0_placeholder_s2g2 B_un_s0_placeholder_s2g2 WLON_s0_placeholder PL VB_s0_placeholder cell_candidate3_bd wcap=2.000000e-06 lcap=1.000000e-06 wacc=6.000000e-07 lacc=5.500000e-07 bden=1 prog=0 dyn=0
VM_pm_s0_placeholder_s2g2 BLS_s0_placeholder B_pm_s0_placeholder_s2g2 0
X_pm_s0_placeholder_s2g2 B_pm_s0_placeholder_s2g2 WLON_s0_placeholder PL VB_s0_placeholder cell_candidate3_bd wcap=2.000000e-06 lcap=1.000000e-06 wacc=6.000000e-07 lacc=5.500000e-07 bden=1 prog=1 dyn=0 zrf=0
VM_pw_s0_placeholder_s2g2 BLS_s0_placeholder B_pw_s0_placeholder_s2g2 0
X_pw_s0_placeholder_s2g2 B_pw_s0_placeholder_s2g2 WLON_s0_placeholder PL VB_s0_placeholder cell_candidate3_bd wcap=2.000000e-06 lcap=1.000000e-06 wacc=6.000000e-07 lacc=5.500000e-07 bden=1 prog=1 dyn=0 zrf={bd_zrf_wc}
EBL_s1_wl_neg1 BLS_s1_wl_neg1 0 BL 0 1.000000e+00
VVB_s1_wl_neg1 VB_s1_wl_neg1 0 DC 3.300000e+00
VWLON_s1_wl_neg1 WLON_s1_wl_neg1 0 DC -1.000000e+00
VM_off_s1_wl_neg1_s1g1_lo BLS_s1_wl_neg1 B_off_s1_wl_neg1_s1g1_lo 0
X_off_s1_wl_neg1_s1g1_lo B_off_s1_wl_neg1_s1g1_lo WLLO PL VB_s1_wl_neg1 cell_candidate3_bd wcap=1.000000e-06 lcap=1.000000e-06 wacc=3.000000e-07 lacc=5.500000e-07 bden=1 prog=0 dyn=0
VM_off_s1_wl_neg1_s1g1_mid BLS_s1_wl_neg1 B_off_s1_wl_neg1_s1g1_mid 0
X_off_s1_wl_neg1_s1g1_mid B_off_s1_wl_neg1_s1g1_mid WLMID PL VB_s1_wl_neg1 cell_candidate3_bd wcap=1.000000e-06 lcap=1.000000e-06 wacc=3.000000e-07 lacc=5.500000e-07 bden=1 prog=0 dyn=0
VM_off_s1_wl_neg1_s1g1_hi BLS_s1_wl_neg1 B_off_s1_wl_neg1_s1g1_hi 0
X_off_s1_wl_neg1_s1g1_hi B_off_s1_wl_neg1_s1g1_hi WLHI PL VB_s1_wl_neg1 cell_candidate3_bd wcap=1.000000e-06 lcap=1.000000e-06 wacc=3.000000e-07 lacc=5.500000e-07 bden=1 prog=0 dyn=0
VM_offp_s1_wl_neg1_s1g1_lo BLS_s1_wl_neg1 B_offp_s1_wl_neg1_s1g1_lo 0
X_offp_s1_wl_neg1_s1g1_lo B_offp_s1_wl_neg1_s1g1_lo WLLO PL VB_s1_wl_neg1 cell_candidate3_bd wcap=1.000000e-06 lcap=1.000000e-06 wacc=3.000000e-07 lacc=5.500000e-07 bden=1 prog=1 dyn=0 zrf=0
VM_offp_s1_wl_neg1_s1g1_mid BLS_s1_wl_neg1 B_offp_s1_wl_neg1_s1g1_mid 0
X_offp_s1_wl_neg1_s1g1_mid B_offp_s1_wl_neg1_s1g1_mid WLMID PL VB_s1_wl_neg1 cell_candidate3_bd wcap=1.000000e-06 lcap=1.000000e-06 wacc=3.000000e-07 lacc=5.500000e-07 bden=1 prog=1 dyn=0 zrf=0
VM_offp_s1_wl_neg1_s1g1_hi BLS_s1_wl_neg1 B_offp_s1_wl_neg1_s1g1_hi 0
X_offp_s1_wl_neg1_s1g1_hi B_offp_s1_wl_neg1_s1g1_hi WLHI PL VB_s1_wl_neg1 cell_candidate3_bd wcap=1.000000e-06 lcap=1.000000e-06 wacc=3.000000e-07 lacc=5.500000e-07 bden=1 prog=1 dyn=0 zrf=0
VM_un_s1_wl_neg1_s1g1 BLS_s1_wl_neg1 B_un_s1_wl_neg1_s1g1 0
X_un_s1_wl_neg1_s1g1 B_un_s1_wl_neg1_s1g1 WLON_s1_wl_neg1 PL VB_s1_wl_neg1 cell_candidate3_bd wcap=1.000000e-06 lcap=1.000000e-06 wacc=3.000000e-07 lacc=5.500000e-07 bden=1 prog=0 dyn=0
VM_pm_s1_wl_neg1_s1g1 BLS_s1_wl_neg1 B_pm_s1_wl_neg1_s1g1 0
X_pm_s1_wl_neg1_s1g1 B_pm_s1_wl_neg1_s1g1 WLON_s1_wl_neg1 PL VB_s1_wl_neg1 cell_candidate3_bd wcap=1.000000e-06 lcap=1.000000e-06 wacc=3.000000e-07 lacc=5.500000e-07 bden=1 prog=1 dyn=0 zrf=0
VM_pw_s1_wl_neg1_s1g1 BLS_s1_wl_neg1 B_pw_s1_wl_neg1_s1g1 0
X_pw_s1_wl_neg1_s1g1 B_pw_s1_wl_neg1_s1g1 WLON_s1_wl_neg1 PL VB_s1_wl_neg1 cell_candidate3_bd wcap=1.000000e-06 lcap=1.000000e-06 wacc=3.000000e-07 lacc=5.500000e-07 bden=1 prog=1 dyn=0 zrf={bd_zrf_wc}
VM_off_s1_wl_neg1_s1g2_lo BLS_s1_wl_neg1 B_off_s1_wl_neg1_s1g2_lo 0
X_off_s1_wl_neg1_s1g2_lo B_off_s1_wl_neg1_s1g2_lo WLLO PL VB_s1_wl_neg1 cell_candidate3_bd wcap=2.000000e-06 lcap=1.000000e-06 wacc=3.000000e-07 lacc=5.500000e-07 bden=1 prog=0 dyn=0
VM_off_s1_wl_neg1_s1g2_mid BLS_s1_wl_neg1 B_off_s1_wl_neg1_s1g2_mid 0
X_off_s1_wl_neg1_s1g2_mid B_off_s1_wl_neg1_s1g2_mid WLMID PL VB_s1_wl_neg1 cell_candidate3_bd wcap=2.000000e-06 lcap=1.000000e-06 wacc=3.000000e-07 lacc=5.500000e-07 bden=1 prog=0 dyn=0
VM_off_s1_wl_neg1_s1g2_hi BLS_s1_wl_neg1 B_off_s1_wl_neg1_s1g2_hi 0
X_off_s1_wl_neg1_s1g2_hi B_off_s1_wl_neg1_s1g2_hi WLHI PL VB_s1_wl_neg1 cell_candidate3_bd wcap=2.000000e-06 lcap=1.000000e-06 wacc=3.000000e-07 lacc=5.500000e-07 bden=1 prog=0 dyn=0
VM_offp_s1_wl_neg1_s1g2_lo BLS_s1_wl_neg1 B_offp_s1_wl_neg1_s1g2_lo 0
X_offp_s1_wl_neg1_s1g2_lo B_offp_s1_wl_neg1_s1g2_lo WLLO PL VB_s1_wl_neg1 cell_candidate3_bd wcap=2.000000e-06 lcap=1.000000e-06 wacc=3.000000e-07 lacc=5.500000e-07 bden=1 prog=1 dyn=0 zrf=0
VM_offp_s1_wl_neg1_s1g2_mid BLS_s1_wl_neg1 B_offp_s1_wl_neg1_s1g2_mid 0
X_offp_s1_wl_neg1_s1g2_mid B_offp_s1_wl_neg1_s1g2_mid WLMID PL VB_s1_wl_neg1 cell_candidate3_bd wcap=2.000000e-06 lcap=1.000000e-06 wacc=3.000000e-07 lacc=5.500000e-07 bden=1 prog=1 dyn=0 zrf=0
VM_offp_s1_wl_neg1_s1g2_hi BLS_s1_wl_neg1 B_offp_s1_wl_neg1_s1g2_hi 0
X_offp_s1_wl_neg1_s1g2_hi B_offp_s1_wl_neg1_s1g2_hi WLHI PL VB_s1_wl_neg1 cell_candidate3_bd wcap=2.000000e-06 lcap=1.000000e-06 wacc=3.000000e-07 lacc=5.500000e-07 bden=1 prog=1 dyn=0 zrf=0
VM_un_s1_wl_neg1_s1g2 BLS_s1_wl_neg1 B_un_s1_wl_neg1_s1g2 0
X_un_s1_wl_neg1_s1g2 B_un_s1_wl_neg1_s1g2 WLON_s1_wl_neg1 PL VB_s1_wl_neg1 cell_candidate3_bd wcap=2.000000e-06 lcap=1.000000e-06 wacc=3.000000e-07 lacc=5.500000e-07 bden=1 prog=0 dyn=0
VM_pm_s1_wl_neg1_s1g2 BLS_s1_wl_neg1 B_pm_s1_wl_neg1_s1g2 0
X_pm_s1_wl_neg1_s1g2 B_pm_s1_wl_neg1_s1g2 WLON_s1_wl_neg1 PL VB_s1_wl_neg1 cell_candidate3_bd wcap=2.000000e-06 lcap=1.000000e-06 wacc=3.000000e-07 lacc=5.500000e-07 bden=1 prog=1 dyn=0 zrf=0
VM_pw_s1_wl_neg1_s1g2 BLS_s1_wl_neg1 B_pw_s1_wl_neg1_s1g2 0
X_pw_s1_wl_neg1_s1g2 B_pw_s1_wl_neg1_s1g2 WLON_s1_wl_neg1 PL VB_s1_wl_neg1 cell_candidate3_bd wcap=2.000000e-06 lcap=1.000000e-06 wacc=3.000000e-07 lacc=5.500000e-07 bden=1 prog=1 dyn=0 zrf={bd_zrf_wc}
VM_off_s1_wl_neg1_s2g1_lo BLS_s1_wl_neg1 B_off_s1_wl_neg1_s2g1_lo 0
X_off_s1_wl_neg1_s2g1_lo B_off_s1_wl_neg1_s2g1_lo WLLO PL VB_s1_wl_neg1 cell_candidate3_bd wcap=1.000000e-06 lcap=1.000000e-06 wacc=6.000000e-07 lacc=5.500000e-07 bden=1 prog=0 dyn=0
VM_off_s1_wl_neg1_s2g1_mid BLS_s1_wl_neg1 B_off_s1_wl_neg1_s2g1_mid 0
X_off_s1_wl_neg1_s2g1_mid B_off_s1_wl_neg1_s2g1_mid WLMID PL VB_s1_wl_neg1 cell_candidate3_bd wcap=1.000000e-06 lcap=1.000000e-06 wacc=6.000000e-07 lacc=5.500000e-07 bden=1 prog=0 dyn=0
VM_off_s1_wl_neg1_s2g1_hi BLS_s1_wl_neg1 B_off_s1_wl_neg1_s2g1_hi 0
X_off_s1_wl_neg1_s2g1_hi B_off_s1_wl_neg1_s2g1_hi WLHI PL VB_s1_wl_neg1 cell_candidate3_bd wcap=1.000000e-06 lcap=1.000000e-06 wacc=6.000000e-07 lacc=5.500000e-07 bden=1 prog=0 dyn=0
VM_offp_s1_wl_neg1_s2g1_lo BLS_s1_wl_neg1 B_offp_s1_wl_neg1_s2g1_lo 0
X_offp_s1_wl_neg1_s2g1_lo B_offp_s1_wl_neg1_s2g1_lo WLLO PL VB_s1_wl_neg1 cell_candidate3_bd wcap=1.000000e-06 lcap=1.000000e-06 wacc=6.000000e-07 lacc=5.500000e-07 bden=1 prog=1 dyn=0 zrf=0
VM_offp_s1_wl_neg1_s2g1_mid BLS_s1_wl_neg1 B_offp_s1_wl_neg1_s2g1_mid 0
X_offp_s1_wl_neg1_s2g1_mid B_offp_s1_wl_neg1_s2g1_mid WLMID PL VB_s1_wl_neg1 cell_candidate3_bd wcap=1.000000e-06 lcap=1.000000e-06 wacc=6.000000e-07 lacc=5.500000e-07 bden=1 prog=1 dyn=0 zrf=0
VM_offp_s1_wl_neg1_s2g1_hi BLS_s1_wl_neg1 B_offp_s1_wl_neg1_s2g1_hi 0
X_offp_s1_wl_neg1_s2g1_hi B_offp_s1_wl_neg1_s2g1_hi WLHI PL VB_s1_wl_neg1 cell_candidate3_bd wcap=1.000000e-06 lcap=1.000000e-06 wacc=6.000000e-07 lacc=5.500000e-07 bden=1 prog=1 dyn=0 zrf=0
VM_un_s1_wl_neg1_s2g1 BLS_s1_wl_neg1 B_un_s1_wl_neg1_s2g1 0
X_un_s1_wl_neg1_s2g1 B_un_s1_wl_neg1_s2g1 WLON_s1_wl_neg1 PL VB_s1_wl_neg1 cell_candidate3_bd wcap=1.000000e-06 lcap=1.000000e-06 wacc=6.000000e-07 lacc=5.500000e-07 bden=1 prog=0 dyn=0
VM_pm_s1_wl_neg1_s2g1 BLS_s1_wl_neg1 B_pm_s1_wl_neg1_s2g1 0
X_pm_s1_wl_neg1_s2g1 B_pm_s1_wl_neg1_s2g1 WLON_s1_wl_neg1 PL VB_s1_wl_neg1 cell_candidate3_bd wcap=1.000000e-06 lcap=1.000000e-06 wacc=6.000000e-07 lacc=5.500000e-07 bden=1 prog=1 dyn=0 zrf=0
VM_pw_s1_wl_neg1_s2g1 BLS_s1_wl_neg1 B_pw_s1_wl_neg1_s2g1 0
X_pw_s1_wl_neg1_s2g1 B_pw_s1_wl_neg1_s2g1 WLON_s1_wl_neg1 PL VB_s1_wl_neg1 cell_candidate3_bd wcap=1.000000e-06 lcap=1.000000e-06 wacc=6.000000e-07 lacc=5.500000e-07 bden=1 prog=1 dyn=0 zrf={bd_zrf_wc}
VM_off_s1_wl_neg1_s2g2_lo BLS_s1_wl_neg1 B_off_s1_wl_neg1_s2g2_lo 0
X_off_s1_wl_neg1_s2g2_lo B_off_s1_wl_neg1_s2g2_lo WLLO PL VB_s1_wl_neg1 cell_candidate3_bd wcap=2.000000e-06 lcap=1.000000e-06 wacc=6.000000e-07 lacc=5.500000e-07 bden=1 prog=0 dyn=0
VM_off_s1_wl_neg1_s2g2_mid BLS_s1_wl_neg1 B_off_s1_wl_neg1_s2g2_mid 0
X_off_s1_wl_neg1_s2g2_mid B_off_s1_wl_neg1_s2g2_mid WLMID PL VB_s1_wl_neg1 cell_candidate3_bd wcap=2.000000e-06 lcap=1.000000e-06 wacc=6.000000e-07 lacc=5.500000e-07 bden=1 prog=0 dyn=0
VM_off_s1_wl_neg1_s2g2_hi BLS_s1_wl_neg1 B_off_s1_wl_neg1_s2g2_hi 0
X_off_s1_wl_neg1_s2g2_hi B_off_s1_wl_neg1_s2g2_hi WLHI PL VB_s1_wl_neg1 cell_candidate3_bd wcap=2.000000e-06 lcap=1.000000e-06 wacc=6.000000e-07 lacc=5.500000e-07 bden=1 prog=0 dyn=0
VM_offp_s1_wl_neg1_s2g2_lo BLS_s1_wl_neg1 B_offp_s1_wl_neg1_s2g2_lo 0
X_offp_s1_wl_neg1_s2g2_lo B_offp_s1_wl_neg1_s2g2_lo WLLO PL VB_s1_wl_neg1 cell_candidate3_bd wcap=2.000000e-06 lcap=1.000000e-06 wacc=6.000000e-07 lacc=5.500000e-07 bden=1 prog=1 dyn=0 zrf=0
VM_offp_s1_wl_neg1_s2g2_mid BLS_s1_wl_neg1 B_offp_s1_wl_neg1_s2g2_mid 0
X_offp_s1_wl_neg1_s2g2_mid B_offp_s1_wl_neg1_s2g2_mid WLMID PL VB_s1_wl_neg1 cell_candidate3_bd wcap=2.000000e-06 lcap=1.000000e-06 wacc=6.000000e-07 lacc=5.500000e-07 bden=1 prog=1 dyn=0 zrf=0
VM_offp_s1_wl_neg1_s2g2_hi BLS_s1_wl_neg1 B_offp_s1_wl_neg1_s2g2_hi 0
X_offp_s1_wl_neg1_s2g2_hi B_offp_s1_wl_neg1_s2g2_hi WLHI PL VB_s1_wl_neg1 cell_candidate3_bd wcap=2.000000e-06 lcap=1.000000e-06 wacc=6.000000e-07 lacc=5.500000e-07 bden=1 prog=1 dyn=0 zrf=0
VM_un_s1_wl_neg1_s2g2 BLS_s1_wl_neg1 B_un_s1_wl_neg1_s2g2 0
X_un_s1_wl_neg1_s2g2 B_un_s1_wl_neg1_s2g2 WLON_s1_wl_neg1 PL VB_s1_wl_neg1 cell_candidate3_bd wcap=2.000000e-06 lcap=1.000000e-06 wacc=6.000000e-07 lacc=5.500000e-07 bden=1 prog=0 dyn=0
VM_pm_s1_wl_neg1_s2g2 BLS_s1_wl_neg1 B_pm_s1_wl_neg1_s2g2 0
X_pm_s1_wl_neg1_s2g2 B_pm_s1_wl_neg1_s2g2 WLON_s1_wl_neg1 PL VB_s1_wl_neg1 cell_candidate3_bd wcap=2.000000e-06 lcap=1.000000e-06 wacc=6.000000e-07 lacc=5.500000e-07 bden=1 prog=1 dyn=0 zrf=0
VM_pw_s1_wl_neg1_s2g2 BLS_s1_wl_neg1 B_pw_s1_wl_neg1_s2g2 0
X_pw_s1_wl_neg1_s2g2 B_pw_s1_wl_neg1_s2g2 WLON_s1_wl_neg1 PL VB_s1_wl_neg1 cell_candidate3_bd wcap=2.000000e-06 lcap=1.000000e-06 wacc=6.000000e-07 lacc=5.500000e-07 bden=1 prog=1 dyn=0 zrf={bd_zrf_wc}
EBL_s2_wl_neg2 BLS_s2_wl_neg2 0 BL 0 1.000000e+00
VVB_s2_wl_neg2 VB_s2_wl_neg2 0 DC 3.300000e+00
VWLON_s2_wl_neg2 WLON_s2_wl_neg2 0 DC -2.000000e+00
VM_off_s2_wl_neg2_s1g1_lo BLS_s2_wl_neg2 B_off_s2_wl_neg2_s1g1_lo 0
X_off_s2_wl_neg2_s1g1_lo B_off_s2_wl_neg2_s1g1_lo WLLO PL VB_s2_wl_neg2 cell_candidate3_bd wcap=1.000000e-06 lcap=1.000000e-06 wacc=3.000000e-07 lacc=5.500000e-07 bden=1 prog=0 dyn=0
VM_off_s2_wl_neg2_s1g1_mid BLS_s2_wl_neg2 B_off_s2_wl_neg2_s1g1_mid 0
X_off_s2_wl_neg2_s1g1_mid B_off_s2_wl_neg2_s1g1_mid WLMID PL VB_s2_wl_neg2 cell_candidate3_bd wcap=1.000000e-06 lcap=1.000000e-06 wacc=3.000000e-07 lacc=5.500000e-07 bden=1 prog=0 dyn=0
VM_off_s2_wl_neg2_s1g1_hi BLS_s2_wl_neg2 B_off_s2_wl_neg2_s1g1_hi 0
X_off_s2_wl_neg2_s1g1_hi B_off_s2_wl_neg2_s1g1_hi WLHI PL VB_s2_wl_neg2 cell_candidate3_bd wcap=1.000000e-06 lcap=1.000000e-06 wacc=3.000000e-07 lacc=5.500000e-07 bden=1 prog=0 dyn=0
VM_offp_s2_wl_neg2_s1g1_lo BLS_s2_wl_neg2 B_offp_s2_wl_neg2_s1g1_lo 0
X_offp_s2_wl_neg2_s1g1_lo B_offp_s2_wl_neg2_s1g1_lo WLLO PL VB_s2_wl_neg2 cell_candidate3_bd wcap=1.000000e-06 lcap=1.000000e-06 wacc=3.000000e-07 lacc=5.500000e-07 bden=1 prog=1 dyn=0 zrf=0
VM_offp_s2_wl_neg2_s1g1_mid BLS_s2_wl_neg2 B_offp_s2_wl_neg2_s1g1_mid 0
X_offp_s2_wl_neg2_s1g1_mid B_offp_s2_wl_neg2_s1g1_mid WLMID PL VB_s2_wl_neg2 cell_candidate3_bd wcap=1.000000e-06 lcap=1.000000e-06 wacc=3.000000e-07 lacc=5.500000e-07 bden=1 prog=1 dyn=0 zrf=0
VM_offp_s2_wl_neg2_s1g1_hi BLS_s2_wl_neg2 B_offp_s2_wl_neg2_s1g1_hi 0
X_offp_s2_wl_neg2_s1g1_hi B_offp_s2_wl_neg2_s1g1_hi WLHI PL VB_s2_wl_neg2 cell_candidate3_bd wcap=1.000000e-06 lcap=1.000000e-06 wacc=3.000000e-07 lacc=5.500000e-07 bden=1 prog=1 dyn=0 zrf=0
VM_un_s2_wl_neg2_s1g1 BLS_s2_wl_neg2 B_un_s2_wl_neg2_s1g1 0
X_un_s2_wl_neg2_s1g1 B_un_s2_wl_neg2_s1g1 WLON_s2_wl_neg2 PL VB_s2_wl_neg2 cell_candidate3_bd wcap=1.000000e-06 lcap=1.000000e-06 wacc=3.000000e-07 lacc=5.500000e-07 bden=1 prog=0 dyn=0
VM_pm_s2_wl_neg2_s1g1 BLS_s2_wl_neg2 B_pm_s2_wl_neg2_s1g1 0
X_pm_s2_wl_neg2_s1g1 B_pm_s2_wl_neg2_s1g1 WLON_s2_wl_neg2 PL VB_s2_wl_neg2 cell_candidate3_bd wcap=1.000000e-06 lcap=1.000000e-06 wacc=3.000000e-07 lacc=5.500000e-07 bden=1 prog=1 dyn=0 zrf=0
VM_pw_s2_wl_neg2_s1g1 BLS_s2_wl_neg2 B_pw_s2_wl_neg2_s1g1 0
X_pw_s2_wl_neg2_s1g1 B_pw_s2_wl_neg2_s1g1 WLON_s2_wl_neg2 PL VB_s2_wl_neg2 cell_candidate3_bd wcap=1.000000e-06 lcap=1.000000e-06 wacc=3.000000e-07 lacc=5.500000e-07 bden=1 prog=1 dyn=0 zrf={bd_zrf_wc}
VM_off_s2_wl_neg2_s1g2_lo BLS_s2_wl_neg2 B_off_s2_wl_neg2_s1g2_lo 0
X_off_s2_wl_neg2_s1g2_lo B_off_s2_wl_neg2_s1g2_lo WLLO PL VB_s2_wl_neg2 cell_candidate3_bd wcap=2.000000e-06 lcap=1.000000e-06 wacc=3.000000e-07 lacc=5.500000e-07 bden=1 prog=0 dyn=0
VM_off_s2_wl_neg2_s1g2_mid BLS_s2_wl_neg2 B_off_s2_wl_neg2_s1g2_mid 0
X_off_s2_wl_neg2_s1g2_mid B_off_s2_wl_neg2_s1g2_mid WLMID PL VB_s2_wl_neg2 cell_candidate3_bd wcap=2.000000e-06 lcap=1.000000e-06 wacc=3.000000e-07 lacc=5.500000e-07 bden=1 prog=0 dyn=0
VM_off_s2_wl_neg2_s1g2_hi BLS_s2_wl_neg2 B_off_s2_wl_neg2_s1g2_hi 0
X_off_s2_wl_neg2_s1g2_hi B_off_s2_wl_neg2_s1g2_hi WLHI PL VB_s2_wl_neg2 cell_candidate3_bd wcap=2.000000e-06 lcap=1.000000e-06 wacc=3.000000e-07 lacc=5.500000e-07 bden=1 prog=0 dyn=0
VM_offp_s2_wl_neg2_s1g2_lo BLS_s2_wl_neg2 B_offp_s2_wl_neg2_s1g2_lo 0
X_offp_s2_wl_neg2_s1g2_lo B_offp_s2_wl_neg2_s1g2_lo WLLO PL VB_s2_wl_neg2 cell_candidate3_bd wcap=2.000000e-06 lcap=1.000000e-06 wacc=3.000000e-07 lacc=5.500000e-07 bden=1 prog=1 dyn=0 zrf=0
VM_offp_s2_wl_neg2_s1g2_mid BLS_s2_wl_neg2 B_offp_s2_wl_neg2_s1g2_mid 0
X_offp_s2_wl_neg2_s1g2_mid B_offp_s2_wl_neg2_s1g2_mid WLMID PL VB_s2_wl_neg2 cell_candidate3_bd wcap=2.000000e-06 lcap=1.000000e-06 wacc=3.000000e-07 lacc=5.500000e-07 bden=1 prog=1 dyn=0 zrf=0
VM_offp_s2_wl_neg2_s1g2_hi BLS_s2_wl_neg2 B_offp_s2_wl_neg2_s1g2_hi 0
X_offp_s2_wl_neg2_s1g2_hi B_offp_s2_wl_neg2_s1g2_hi WLHI PL VB_s2_wl_neg2 cell_candidate3_bd wcap=2.000000e-06 lcap=1.000000e-06 wacc=3.000000e-07 lacc=5.500000e-07 bden=1 prog=1 dyn=0 zrf=0
VM_un_s2_wl_neg2_s1g2 BLS_s2_wl_neg2 B_un_s2_wl_neg2_s1g2 0
X_un_s2_wl_neg2_s1g2 B_un_s2_wl_neg2_s1g2 WLON_s2_wl_neg2 PL VB_s2_wl_neg2 cell_candidate3_bd wcap=2.000000e-06 lcap=1.000000e-06 wacc=3.000000e-07 lacc=5.500000e-07 bden=1 prog=0 dyn=0
VM_pm_s2_wl_neg2_s1g2 BLS_s2_wl_neg2 B_pm_s2_wl_neg2_s1g2 0
X_pm_s2_wl_neg2_s1g2 B_pm_s2_wl_neg2_s1g2 WLON_s2_wl_neg2 PL VB_s2_wl_neg2 cell_candidate3_bd wcap=2.000000e-06 lcap=1.000000e-06 wacc=3.000000e-07 lacc=5.500000e-07 bden=1 prog=1 dyn=0 zrf=0
VM_pw_s2_wl_neg2_s1g2 BLS_s2_wl_neg2 B_pw_s2_wl_neg2_s1g2 0
X_pw_s2_wl_neg2_s1g2 B_pw_s2_wl_neg2_s1g2 WLON_s2_wl_neg2 PL VB_s2_wl_neg2 cell_candidate3_bd wcap=2.000000e-06 lcap=1.000000e-06 wacc=3.000000e-07 lacc=5.500000e-07 bden=1 prog=1 dyn=0 zrf={bd_zrf_wc}
VM_off_s2_wl_neg2_s2g1_lo BLS_s2_wl_neg2 B_off_s2_wl_neg2_s2g1_lo 0
X_off_s2_wl_neg2_s2g1_lo B_off_s2_wl_neg2_s2g1_lo WLLO PL VB_s2_wl_neg2 cell_candidate3_bd wcap=1.000000e-06 lcap=1.000000e-06 wacc=6.000000e-07 lacc=5.500000e-07 bden=1 prog=0 dyn=0
VM_off_s2_wl_neg2_s2g1_mid BLS_s2_wl_neg2 B_off_s2_wl_neg2_s2g1_mid 0
X_off_s2_wl_neg2_s2g1_mid B_off_s2_wl_neg2_s2g1_mid WLMID PL VB_s2_wl_neg2 cell_candidate3_bd wcap=1.000000e-06 lcap=1.000000e-06 wacc=6.000000e-07 lacc=5.500000e-07 bden=1 prog=0 dyn=0
VM_off_s2_wl_neg2_s2g1_hi BLS_s2_wl_neg2 B_off_s2_wl_neg2_s2g1_hi 0
X_off_s2_wl_neg2_s2g1_hi B_off_s2_wl_neg2_s2g1_hi WLHI PL VB_s2_wl_neg2 cell_candidate3_bd wcap=1.000000e-06 lcap=1.000000e-06 wacc=6.000000e-07 lacc=5.500000e-07 bden=1 prog=0 dyn=0
VM_offp_s2_wl_neg2_s2g1_lo BLS_s2_wl_neg2 B_offp_s2_wl_neg2_s2g1_lo 0
X_offp_s2_wl_neg2_s2g1_lo B_offp_s2_wl_neg2_s2g1_lo WLLO PL VB_s2_wl_neg2 cell_candidate3_bd wcap=1.000000e-06 lcap=1.000000e-06 wacc=6.000000e-07 lacc=5.500000e-07 bden=1 prog=1 dyn=0 zrf=0
VM_offp_s2_wl_neg2_s2g1_mid BLS_s2_wl_neg2 B_offp_s2_wl_neg2_s2g1_mid 0
X_offp_s2_wl_neg2_s2g1_mid B_offp_s2_wl_neg2_s2g1_mid WLMID PL VB_s2_wl_neg2 cell_candidate3_bd wcap=1.000000e-06 lcap=1.000000e-06 wacc=6.000000e-07 lacc=5.500000e-07 bden=1 prog=1 dyn=0 zrf=0
VM_offp_s2_wl_neg2_s2g1_hi BLS_s2_wl_neg2 B_offp_s2_wl_neg2_s2g1_hi 0
X_offp_s2_wl_neg2_s2g1_hi B_offp_s2_wl_neg2_s2g1_hi WLHI PL VB_s2_wl_neg2 cell_candidate3_bd wcap=1.000000e-06 lcap=1.000000e-06 wacc=6.000000e-07 lacc=5.500000e-07 bden=1 prog=1 dyn=0 zrf=0
VM_un_s2_wl_neg2_s2g1 BLS_s2_wl_neg2 B_un_s2_wl_neg2_s2g1 0
X_un_s2_wl_neg2_s2g1 B_un_s2_wl_neg2_s2g1 WLON_s2_wl_neg2 PL VB_s2_wl_neg2 cell_candidate3_bd wcap=1.000000e-06 lcap=1.000000e-06 wacc=6.000000e-07 lacc=5.500000e-07 bden=1 prog=0 dyn=0
VM_pm_s2_wl_neg2_s2g1 BLS_s2_wl_neg2 B_pm_s2_wl_neg2_s2g1 0
X_pm_s2_wl_neg2_s2g1 B_pm_s2_wl_neg2_s2g1 WLON_s2_wl_neg2 PL VB_s2_wl_neg2 cell_candidate3_bd wcap=1.000000e-06 lcap=1.000000e-06 wacc=6.000000e-07 lacc=5.500000e-07 bden=1 prog=1 dyn=0 zrf=0
VM_pw_s2_wl_neg2_s2g1 BLS_s2_wl_neg2 B_pw_s2_wl_neg2_s2g1 0
X_pw_s2_wl_neg2_s2g1 B_pw_s2_wl_neg2_s2g1 WLON_s2_wl_neg2 PL VB_s2_wl_neg2 cell_candidate3_bd wcap=1.000000e-06 lcap=1.000000e-06 wacc=6.000000e-07 lacc=5.500000e-07 bden=1 prog=1 dyn=0 zrf={bd_zrf_wc}
VM_off_s2_wl_neg2_s2g2_lo BLS_s2_wl_neg2 B_off_s2_wl_neg2_s2g2_lo 0
X_off_s2_wl_neg2_s2g2_lo B_off_s2_wl_neg2_s2g2_lo WLLO PL VB_s2_wl_neg2 cell_candidate3_bd wcap=2.000000e-06 lcap=1.000000e-06 wacc=6.000000e-07 lacc=5.500000e-07 bden=1 prog=0 dyn=0
VM_off_s2_wl_neg2_s2g2_mid BLS_s2_wl_neg2 B_off_s2_wl_neg2_s2g2_mid 0
X_off_s2_wl_neg2_s2g2_mid B_off_s2_wl_neg2_s2g2_mid WLMID PL VB_s2_wl_neg2 cell_candidate3_bd wcap=2.000000e-06 lcap=1.000000e-06 wacc=6.000000e-07 lacc=5.500000e-07 bden=1 prog=0 dyn=0
VM_off_s2_wl_neg2_s2g2_hi BLS_s2_wl_neg2 B_off_s2_wl_neg2_s2g2_hi 0
X_off_s2_wl_neg2_s2g2_hi B_off_s2_wl_neg2_s2g2_hi WLHI PL VB_s2_wl_neg2 cell_candidate3_bd wcap=2.000000e-06 lcap=1.000000e-06 wacc=6.000000e-07 lacc=5.500000e-07 bden=1 prog=0 dyn=0
VM_offp_s2_wl_neg2_s2g2_lo BLS_s2_wl_neg2 B_offp_s2_wl_neg2_s2g2_lo 0
X_offp_s2_wl_neg2_s2g2_lo B_offp_s2_wl_neg2_s2g2_lo WLLO PL VB_s2_wl_neg2 cell_candidate3_bd wcap=2.000000e-06 lcap=1.000000e-06 wacc=6.000000e-07 lacc=5.500000e-07 bden=1 prog=1 dyn=0 zrf=0
VM_offp_s2_wl_neg2_s2g2_mid BLS_s2_wl_neg2 B_offp_s2_wl_neg2_s2g2_mid 0
X_offp_s2_wl_neg2_s2g2_mid B_offp_s2_wl_neg2_s2g2_mid WLMID PL VB_s2_wl_neg2 cell_candidate3_bd wcap=2.000000e-06 lcap=1.000000e-06 wacc=6.000000e-07 lacc=5.500000e-07 bden=1 prog=1 dyn=0 zrf=0
VM_offp_s2_wl_neg2_s2g2_hi BLS_s2_wl_neg2 B_offp_s2_wl_neg2_s2g2_hi 0
X_offp_s2_wl_neg2_s2g2_hi B_offp_s2_wl_neg2_s2g2_hi WLHI PL VB_s2_wl_neg2 cell_candidate3_bd wcap=2.000000e-06 lcap=1.000000e-06 wacc=6.000000e-07 lacc=5.500000e-07 bden=1 prog=1 dyn=0 zrf=0
VM_un_s2_wl_neg2_s2g2 BLS_s2_wl_neg2 B_un_s2_wl_neg2_s2g2 0
X_un_s2_wl_neg2_s2g2 B_un_s2_wl_neg2_s2g2 WLON_s2_wl_neg2 PL VB_s2_wl_neg2 cell_candidate3_bd wcap=2.000000e-06 lcap=1.000000e-06 wacc=6.000000e-07 lacc=5.500000e-07 bden=1 prog=0 dyn=0
VM_pm_s2_wl_neg2_s2g2 BLS_s2_wl_neg2 B_pm_s2_wl_neg2_s2g2 0
X_pm_s2_wl_neg2_s2g2 B_pm_s2_wl_neg2_s2g2 WLON_s2_wl_neg2 PL VB_s2_wl_neg2 cell_candidate3_bd wcap=2.000000e-06 lcap=1.000000e-06 wacc=6.000000e-07 lacc=5.500000e-07 bden=1 prog=1 dyn=0 zrf=0
VM_pw_s2_wl_neg2_s2g2 BLS_s2_wl_neg2 B_pw_s2_wl_neg2_s2g2 0
X_pw_s2_wl_neg2_s2g2 B_pw_s2_wl_neg2_s2g2 WLON_s2_wl_neg2 PL VB_s2_wl_neg2 cell_candidate3_bd wcap=2.000000e-06 lcap=1.000000e-06 wacc=6.000000e-07 lacc=5.500000e-07 bden=1 prog=1 dyn=0 zrf={bd_zrf_wc}
EBL_s3_vb_track BLS_s3_vb_track 0 BL 0 1.000000e+00
BVB_s3_vb_track VB_s3_vb_track 0 V = 'v(bls_s3_vb_track) + 0.000000e+00'
VWLON_s3_vb_track WLON_s3_vb_track 0 DC 0.000000e+00
VM_off_s3_vb_track_s1g1_lo BLS_s3_vb_track B_off_s3_vb_track_s1g1_lo 0
X_off_s3_vb_track_s1g1_lo B_off_s3_vb_track_s1g1_lo WLLO PL VB_s3_vb_track cell_candidate3_bd wcap=1.000000e-06 lcap=1.000000e-06 wacc=3.000000e-07 lacc=5.500000e-07 bden=1 prog=0 dyn=0
VM_off_s3_vb_track_s1g1_mid BLS_s3_vb_track B_off_s3_vb_track_s1g1_mid 0
X_off_s3_vb_track_s1g1_mid B_off_s3_vb_track_s1g1_mid WLMID PL VB_s3_vb_track cell_candidate3_bd wcap=1.000000e-06 lcap=1.000000e-06 wacc=3.000000e-07 lacc=5.500000e-07 bden=1 prog=0 dyn=0
VM_off_s3_vb_track_s1g1_hi BLS_s3_vb_track B_off_s3_vb_track_s1g1_hi 0
X_off_s3_vb_track_s1g1_hi B_off_s3_vb_track_s1g1_hi WLHI PL VB_s3_vb_track cell_candidate3_bd wcap=1.000000e-06 lcap=1.000000e-06 wacc=3.000000e-07 lacc=5.500000e-07 bden=1 prog=0 dyn=0
VM_offp_s3_vb_track_s1g1_lo BLS_s3_vb_track B_offp_s3_vb_track_s1g1_lo 0
X_offp_s3_vb_track_s1g1_lo B_offp_s3_vb_track_s1g1_lo WLLO PL VB_s3_vb_track cell_candidate3_bd wcap=1.000000e-06 lcap=1.000000e-06 wacc=3.000000e-07 lacc=5.500000e-07 bden=1 prog=1 dyn=0 zrf=0
VM_offp_s3_vb_track_s1g1_mid BLS_s3_vb_track B_offp_s3_vb_track_s1g1_mid 0
X_offp_s3_vb_track_s1g1_mid B_offp_s3_vb_track_s1g1_mid WLMID PL VB_s3_vb_track cell_candidate3_bd wcap=1.000000e-06 lcap=1.000000e-06 wacc=3.000000e-07 lacc=5.500000e-07 bden=1 prog=1 dyn=0 zrf=0
VM_offp_s3_vb_track_s1g1_hi BLS_s3_vb_track B_offp_s3_vb_track_s1g1_hi 0
X_offp_s3_vb_track_s1g1_hi B_offp_s3_vb_track_s1g1_hi WLHI PL VB_s3_vb_track cell_candidate3_bd wcap=1.000000e-06 lcap=1.000000e-06 wacc=3.000000e-07 lacc=5.500000e-07 bden=1 prog=1 dyn=0 zrf=0
VM_un_s3_vb_track_s1g1 BLS_s3_vb_track B_un_s3_vb_track_s1g1 0
X_un_s3_vb_track_s1g1 B_un_s3_vb_track_s1g1 WLON_s3_vb_track PL VB_s3_vb_track cell_candidate3_bd wcap=1.000000e-06 lcap=1.000000e-06 wacc=3.000000e-07 lacc=5.500000e-07 bden=1 prog=0 dyn=0
VM_pm_s3_vb_track_s1g1 BLS_s3_vb_track B_pm_s3_vb_track_s1g1 0
X_pm_s3_vb_track_s1g1 B_pm_s3_vb_track_s1g1 WLON_s3_vb_track PL VB_s3_vb_track cell_candidate3_bd wcap=1.000000e-06 lcap=1.000000e-06 wacc=3.000000e-07 lacc=5.500000e-07 bden=1 prog=1 dyn=0 zrf=0
VM_pw_s3_vb_track_s1g1 BLS_s3_vb_track B_pw_s3_vb_track_s1g1 0
X_pw_s3_vb_track_s1g1 B_pw_s3_vb_track_s1g1 WLON_s3_vb_track PL VB_s3_vb_track cell_candidate3_bd wcap=1.000000e-06 lcap=1.000000e-06 wacc=3.000000e-07 lacc=5.500000e-07 bden=1 prog=1 dyn=0 zrf={bd_zrf_wc}
VM_off_s3_vb_track_s1g2_lo BLS_s3_vb_track B_off_s3_vb_track_s1g2_lo 0
X_off_s3_vb_track_s1g2_lo B_off_s3_vb_track_s1g2_lo WLLO PL VB_s3_vb_track cell_candidate3_bd wcap=2.000000e-06 lcap=1.000000e-06 wacc=3.000000e-07 lacc=5.500000e-07 bden=1 prog=0 dyn=0
VM_off_s3_vb_track_s1g2_mid BLS_s3_vb_track B_off_s3_vb_track_s1g2_mid 0
X_off_s3_vb_track_s1g2_mid B_off_s3_vb_track_s1g2_mid WLMID PL VB_s3_vb_track cell_candidate3_bd wcap=2.000000e-06 lcap=1.000000e-06 wacc=3.000000e-07 lacc=5.500000e-07 bden=1 prog=0 dyn=0
VM_off_s3_vb_track_s1g2_hi BLS_s3_vb_track B_off_s3_vb_track_s1g2_hi 0
X_off_s3_vb_track_s1g2_hi B_off_s3_vb_track_s1g2_hi WLHI PL VB_s3_vb_track cell_candidate3_bd wcap=2.000000e-06 lcap=1.000000e-06 wacc=3.000000e-07 lacc=5.500000e-07 bden=1 prog=0 dyn=0
VM_offp_s3_vb_track_s1g2_lo BLS_s3_vb_track B_offp_s3_vb_track_s1g2_lo 0
X_offp_s3_vb_track_s1g2_lo B_offp_s3_vb_track_s1g2_lo WLLO PL VB_s3_vb_track cell_candidate3_bd wcap=2.000000e-06 lcap=1.000000e-06 wacc=3.000000e-07 lacc=5.500000e-07 bden=1 prog=1 dyn=0 zrf=0
VM_offp_s3_vb_track_s1g2_mid BLS_s3_vb_track B_offp_s3_vb_track_s1g2_mid 0
X_offp_s3_vb_track_s1g2_mid B_offp_s3_vb_track_s1g2_mid WLMID PL VB_s3_vb_track cell_candidate3_bd wcap=2.000000e-06 lcap=1.000000e-06 wacc=3.000000e-07 lacc=5.500000e-07 bden=1 prog=1 dyn=0 zrf=0
VM_offp_s3_vb_track_s1g2_hi BLS_s3_vb_track B_offp_s3_vb_track_s1g2_hi 0
X_offp_s3_vb_track_s1g2_hi B_offp_s3_vb_track_s1g2_hi WLHI PL VB_s3_vb_track cell_candidate3_bd wcap=2.000000e-06 lcap=1.000000e-06 wacc=3.000000e-07 lacc=5.500000e-07 bden=1 prog=1 dyn=0 zrf=0
VM_un_s3_vb_track_s1g2 BLS_s3_vb_track B_un_s3_vb_track_s1g2 0
X_un_s3_vb_track_s1g2 B_un_s3_vb_track_s1g2 WLON_s3_vb_track PL VB_s3_vb_track cell_candidate3_bd wcap=2.000000e-06 lcap=1.000000e-06 wacc=3.000000e-07 lacc=5.500000e-07 bden=1 prog=0 dyn=0
VM_pm_s3_vb_track_s1g2 BLS_s3_vb_track B_pm_s3_vb_track_s1g2 0
X_pm_s3_vb_track_s1g2 B_pm_s3_vb_track_s1g2 WLON_s3_vb_track PL VB_s3_vb_track cell_candidate3_bd wcap=2.000000e-06 lcap=1.000000e-06 wacc=3.000000e-07 lacc=5.500000e-07 bden=1 prog=1 dyn=0 zrf=0
VM_pw_s3_vb_track_s1g2 BLS_s3_vb_track B_pw_s3_vb_track_s1g2 0
X_pw_s3_vb_track_s1g2 B_pw_s3_vb_track_s1g2 WLON_s3_vb_track PL VB_s3_vb_track cell_candidate3_bd wcap=2.000000e-06 lcap=1.000000e-06 wacc=3.000000e-07 lacc=5.500000e-07 bden=1 prog=1 dyn=0 zrf={bd_zrf_wc}
VM_off_s3_vb_track_s2g1_lo BLS_s3_vb_track B_off_s3_vb_track_s2g1_lo 0
X_off_s3_vb_track_s2g1_lo B_off_s3_vb_track_s2g1_lo WLLO PL VB_s3_vb_track cell_candidate3_bd wcap=1.000000e-06 lcap=1.000000e-06 wacc=6.000000e-07 lacc=5.500000e-07 bden=1 prog=0 dyn=0
VM_off_s3_vb_track_s2g1_mid BLS_s3_vb_track B_off_s3_vb_track_s2g1_mid 0
X_off_s3_vb_track_s2g1_mid B_off_s3_vb_track_s2g1_mid WLMID PL VB_s3_vb_track cell_candidate3_bd wcap=1.000000e-06 lcap=1.000000e-06 wacc=6.000000e-07 lacc=5.500000e-07 bden=1 prog=0 dyn=0
VM_off_s3_vb_track_s2g1_hi BLS_s3_vb_track B_off_s3_vb_track_s2g1_hi 0
X_off_s3_vb_track_s2g1_hi B_off_s3_vb_track_s2g1_hi WLHI PL VB_s3_vb_track cell_candidate3_bd wcap=1.000000e-06 lcap=1.000000e-06 wacc=6.000000e-07 lacc=5.500000e-07 bden=1 prog=0 dyn=0
VM_offp_s3_vb_track_s2g1_lo BLS_s3_vb_track B_offp_s3_vb_track_s2g1_lo 0
X_offp_s3_vb_track_s2g1_lo B_offp_s3_vb_track_s2g1_lo WLLO PL VB_s3_vb_track cell_candidate3_bd wcap=1.000000e-06 lcap=1.000000e-06 wacc=6.000000e-07 lacc=5.500000e-07 bden=1 prog=1 dyn=0 zrf=0
VM_offp_s3_vb_track_s2g1_mid BLS_s3_vb_track B_offp_s3_vb_track_s2g1_mid 0
X_offp_s3_vb_track_s2g1_mid B_offp_s3_vb_track_s2g1_mid WLMID PL VB_s3_vb_track cell_candidate3_bd wcap=1.000000e-06 lcap=1.000000e-06 wacc=6.000000e-07 lacc=5.500000e-07 bden=1 prog=1 dyn=0 zrf=0
VM_offp_s3_vb_track_s2g1_hi BLS_s3_vb_track B_offp_s3_vb_track_s2g1_hi 0
X_offp_s3_vb_track_s2g1_hi B_offp_s3_vb_track_s2g1_hi WLHI PL VB_s3_vb_track cell_candidate3_bd wcap=1.000000e-06 lcap=1.000000e-06 wacc=6.000000e-07 lacc=5.500000e-07 bden=1 prog=1 dyn=0 zrf=0
VM_un_s3_vb_track_s2g1 BLS_s3_vb_track B_un_s3_vb_track_s2g1 0
X_un_s3_vb_track_s2g1 B_un_s3_vb_track_s2g1 WLON_s3_vb_track PL VB_s3_vb_track cell_candidate3_bd wcap=1.000000e-06 lcap=1.000000e-06 wacc=6.000000e-07 lacc=5.500000e-07 bden=1 prog=0 dyn=0
VM_pm_s3_vb_track_s2g1 BLS_s3_vb_track B_pm_s3_vb_track_s2g1 0
X_pm_s3_vb_track_s2g1 B_pm_s3_vb_track_s2g1 WLON_s3_vb_track PL VB_s3_vb_track cell_candidate3_bd wcap=1.000000e-06 lcap=1.000000e-06 wacc=6.000000e-07 lacc=5.500000e-07 bden=1 prog=1 dyn=0 zrf=0
VM_pw_s3_vb_track_s2g1 BLS_s3_vb_track B_pw_s3_vb_track_s2g1 0
X_pw_s3_vb_track_s2g1 B_pw_s3_vb_track_s2g1 WLON_s3_vb_track PL VB_s3_vb_track cell_candidate3_bd wcap=1.000000e-06 lcap=1.000000e-06 wacc=6.000000e-07 lacc=5.500000e-07 bden=1 prog=1 dyn=0 zrf={bd_zrf_wc}
VM_off_s3_vb_track_s2g2_lo BLS_s3_vb_track B_off_s3_vb_track_s2g2_lo 0
X_off_s3_vb_track_s2g2_lo B_off_s3_vb_track_s2g2_lo WLLO PL VB_s3_vb_track cell_candidate3_bd wcap=2.000000e-06 lcap=1.000000e-06 wacc=6.000000e-07 lacc=5.500000e-07 bden=1 prog=0 dyn=0
VM_off_s3_vb_track_s2g2_mid BLS_s3_vb_track B_off_s3_vb_track_s2g2_mid 0
X_off_s3_vb_track_s2g2_mid B_off_s3_vb_track_s2g2_mid WLMID PL VB_s3_vb_track cell_candidate3_bd wcap=2.000000e-06 lcap=1.000000e-06 wacc=6.000000e-07 lacc=5.500000e-07 bden=1 prog=0 dyn=0
VM_off_s3_vb_track_s2g2_hi BLS_s3_vb_track B_off_s3_vb_track_s2g2_hi 0
X_off_s3_vb_track_s2g2_hi B_off_s3_vb_track_s2g2_hi WLHI PL VB_s3_vb_track cell_candidate3_bd wcap=2.000000e-06 lcap=1.000000e-06 wacc=6.000000e-07 lacc=5.500000e-07 bden=1 prog=0 dyn=0
VM_offp_s3_vb_track_s2g2_lo BLS_s3_vb_track B_offp_s3_vb_track_s2g2_lo 0
X_offp_s3_vb_track_s2g2_lo B_offp_s3_vb_track_s2g2_lo WLLO PL VB_s3_vb_track cell_candidate3_bd wcap=2.000000e-06 lcap=1.000000e-06 wacc=6.000000e-07 lacc=5.500000e-07 bden=1 prog=1 dyn=0 zrf=0
VM_offp_s3_vb_track_s2g2_mid BLS_s3_vb_track B_offp_s3_vb_track_s2g2_mid 0
X_offp_s3_vb_track_s2g2_mid B_offp_s3_vb_track_s2g2_mid WLMID PL VB_s3_vb_track cell_candidate3_bd wcap=2.000000e-06 lcap=1.000000e-06 wacc=6.000000e-07 lacc=5.500000e-07 bden=1 prog=1 dyn=0 zrf=0
VM_offp_s3_vb_track_s2g2_hi BLS_s3_vb_track B_offp_s3_vb_track_s2g2_hi 0
X_offp_s3_vb_track_s2g2_hi B_offp_s3_vb_track_s2g2_hi WLHI PL VB_s3_vb_track cell_candidate3_bd wcap=2.000000e-06 lcap=1.000000e-06 wacc=6.000000e-07 lacc=5.500000e-07 bden=1 prog=1 dyn=0 zrf=0
VM_un_s3_vb_track_s2g2 BLS_s3_vb_track B_un_s3_vb_track_s2g2 0
X_un_s3_vb_track_s2g2 B_un_s3_vb_track_s2g2 WLON_s3_vb_track PL VB_s3_vb_track cell_candidate3_bd wcap=2.000000e-06 lcap=1.000000e-06 wacc=6.000000e-07 lacc=5.500000e-07 bden=1 prog=0 dyn=0
VM_pm_s3_vb_track_s2g2 BLS_s3_vb_track B_pm_s3_vb_track_s2g2 0
X_pm_s3_vb_track_s2g2 B_pm_s3_vb_track_s2g2 WLON_s3_vb_track PL VB_s3_vb_track cell_candidate3_bd wcap=2.000000e-06 lcap=1.000000e-06 wacc=6.000000e-07 lacc=5.500000e-07 bden=1 prog=1 dyn=0 zrf=0
VM_pw_s3_vb_track_s2g2 BLS_s3_vb_track B_pw_s3_vb_track_s2g2 0
X_pw_s3_vb_track_s2g2 B_pw_s3_vb_track_s2g2 WLON_s3_vb_track PL VB_s3_vb_track cell_candidate3_bd wcap=2.000000e-06 lcap=1.000000e-06 wacc=6.000000e-07 lacc=5.500000e-07 bden=1 prog=1 dyn=0 zrf={bd_zrf_wc}
EBL_s4_vb_fix1v BLS_s4_vb_fix1v 0 BL 0 1.000000e+00
VVB_s4_vb_fix1v VB_s4_vb_fix1v 0 DC 1.000000e+00
VWLON_s4_vb_fix1v WLON_s4_vb_fix1v 0 DC 0.000000e+00
VM_off_s4_vb_fix1v_s1g1_lo BLS_s4_vb_fix1v B_off_s4_vb_fix1v_s1g1_lo 0
X_off_s4_vb_fix1v_s1g1_lo B_off_s4_vb_fix1v_s1g1_lo WLLO PL VB_s4_vb_fix1v cell_candidate3_bd wcap=1.000000e-06 lcap=1.000000e-06 wacc=3.000000e-07 lacc=5.500000e-07 bden=1 prog=0 dyn=0
VM_off_s4_vb_fix1v_s1g1_mid BLS_s4_vb_fix1v B_off_s4_vb_fix1v_s1g1_mid 0
X_off_s4_vb_fix1v_s1g1_mid B_off_s4_vb_fix1v_s1g1_mid WLMID PL VB_s4_vb_fix1v cell_candidate3_bd wcap=1.000000e-06 lcap=1.000000e-06 wacc=3.000000e-07 lacc=5.500000e-07 bden=1 prog=0 dyn=0
VM_off_s4_vb_fix1v_s1g1_hi BLS_s4_vb_fix1v B_off_s4_vb_fix1v_s1g1_hi 0
X_off_s4_vb_fix1v_s1g1_hi B_off_s4_vb_fix1v_s1g1_hi WLHI PL VB_s4_vb_fix1v cell_candidate3_bd wcap=1.000000e-06 lcap=1.000000e-06 wacc=3.000000e-07 lacc=5.500000e-07 bden=1 prog=0 dyn=0
VM_offp_s4_vb_fix1v_s1g1_lo BLS_s4_vb_fix1v B_offp_s4_vb_fix1v_s1g1_lo 0
X_offp_s4_vb_fix1v_s1g1_lo B_offp_s4_vb_fix1v_s1g1_lo WLLO PL VB_s4_vb_fix1v cell_candidate3_bd wcap=1.000000e-06 lcap=1.000000e-06 wacc=3.000000e-07 lacc=5.500000e-07 bden=1 prog=1 dyn=0 zrf=0
VM_offp_s4_vb_fix1v_s1g1_mid BLS_s4_vb_fix1v B_offp_s4_vb_fix1v_s1g1_mid 0
X_offp_s4_vb_fix1v_s1g1_mid B_offp_s4_vb_fix1v_s1g1_mid WLMID PL VB_s4_vb_fix1v cell_candidate3_bd wcap=1.000000e-06 lcap=1.000000e-06 wacc=3.000000e-07 lacc=5.500000e-07 bden=1 prog=1 dyn=0 zrf=0
VM_offp_s4_vb_fix1v_s1g1_hi BLS_s4_vb_fix1v B_offp_s4_vb_fix1v_s1g1_hi 0
X_offp_s4_vb_fix1v_s1g1_hi B_offp_s4_vb_fix1v_s1g1_hi WLHI PL VB_s4_vb_fix1v cell_candidate3_bd wcap=1.000000e-06 lcap=1.000000e-06 wacc=3.000000e-07 lacc=5.500000e-07 bden=1 prog=1 dyn=0 zrf=0
VM_un_s4_vb_fix1v_s1g1 BLS_s4_vb_fix1v B_un_s4_vb_fix1v_s1g1 0
X_un_s4_vb_fix1v_s1g1 B_un_s4_vb_fix1v_s1g1 WLON_s4_vb_fix1v PL VB_s4_vb_fix1v cell_candidate3_bd wcap=1.000000e-06 lcap=1.000000e-06 wacc=3.000000e-07 lacc=5.500000e-07 bden=1 prog=0 dyn=0
VM_pm_s4_vb_fix1v_s1g1 BLS_s4_vb_fix1v B_pm_s4_vb_fix1v_s1g1 0
X_pm_s4_vb_fix1v_s1g1 B_pm_s4_vb_fix1v_s1g1 WLON_s4_vb_fix1v PL VB_s4_vb_fix1v cell_candidate3_bd wcap=1.000000e-06 lcap=1.000000e-06 wacc=3.000000e-07 lacc=5.500000e-07 bden=1 prog=1 dyn=0 zrf=0
VM_pw_s4_vb_fix1v_s1g1 BLS_s4_vb_fix1v B_pw_s4_vb_fix1v_s1g1 0
X_pw_s4_vb_fix1v_s1g1 B_pw_s4_vb_fix1v_s1g1 WLON_s4_vb_fix1v PL VB_s4_vb_fix1v cell_candidate3_bd wcap=1.000000e-06 lcap=1.000000e-06 wacc=3.000000e-07 lacc=5.500000e-07 bden=1 prog=1 dyn=0 zrf={bd_zrf_wc}
VM_off_s4_vb_fix1v_s1g2_lo BLS_s4_vb_fix1v B_off_s4_vb_fix1v_s1g2_lo 0
X_off_s4_vb_fix1v_s1g2_lo B_off_s4_vb_fix1v_s1g2_lo WLLO PL VB_s4_vb_fix1v cell_candidate3_bd wcap=2.000000e-06 lcap=1.000000e-06 wacc=3.000000e-07 lacc=5.500000e-07 bden=1 prog=0 dyn=0
VM_off_s4_vb_fix1v_s1g2_mid BLS_s4_vb_fix1v B_off_s4_vb_fix1v_s1g2_mid 0
X_off_s4_vb_fix1v_s1g2_mid B_off_s4_vb_fix1v_s1g2_mid WLMID PL VB_s4_vb_fix1v cell_candidate3_bd wcap=2.000000e-06 lcap=1.000000e-06 wacc=3.000000e-07 lacc=5.500000e-07 bden=1 prog=0 dyn=0
VM_off_s4_vb_fix1v_s1g2_hi BLS_s4_vb_fix1v B_off_s4_vb_fix1v_s1g2_hi 0
X_off_s4_vb_fix1v_s1g2_hi B_off_s4_vb_fix1v_s1g2_hi WLHI PL VB_s4_vb_fix1v cell_candidate3_bd wcap=2.000000e-06 lcap=1.000000e-06 wacc=3.000000e-07 lacc=5.500000e-07 bden=1 prog=0 dyn=0
VM_offp_s4_vb_fix1v_s1g2_lo BLS_s4_vb_fix1v B_offp_s4_vb_fix1v_s1g2_lo 0
X_offp_s4_vb_fix1v_s1g2_lo B_offp_s4_vb_fix1v_s1g2_lo WLLO PL VB_s4_vb_fix1v cell_candidate3_bd wcap=2.000000e-06 lcap=1.000000e-06 wacc=3.000000e-07 lacc=5.500000e-07 bden=1 prog=1 dyn=0 zrf=0
VM_offp_s4_vb_fix1v_s1g2_mid BLS_s4_vb_fix1v B_offp_s4_vb_fix1v_s1g2_mid 0
X_offp_s4_vb_fix1v_s1g2_mid B_offp_s4_vb_fix1v_s1g2_mid WLMID PL VB_s4_vb_fix1v cell_candidate3_bd wcap=2.000000e-06 lcap=1.000000e-06 wacc=3.000000e-07 lacc=5.500000e-07 bden=1 prog=1 dyn=0 zrf=0
VM_offp_s4_vb_fix1v_s1g2_hi BLS_s4_vb_fix1v B_offp_s4_vb_fix1v_s1g2_hi 0
X_offp_s4_vb_fix1v_s1g2_hi B_offp_s4_vb_fix1v_s1g2_hi WLHI PL VB_s4_vb_fix1v cell_candidate3_bd wcap=2.000000e-06 lcap=1.000000e-06 wacc=3.000000e-07 lacc=5.500000e-07 bden=1 prog=1 dyn=0 zrf=0
VM_un_s4_vb_fix1v_s1g2 BLS_s4_vb_fix1v B_un_s4_vb_fix1v_s1g2 0
X_un_s4_vb_fix1v_s1g2 B_un_s4_vb_fix1v_s1g2 WLON_s4_vb_fix1v PL VB_s4_vb_fix1v cell_candidate3_bd wcap=2.000000e-06 lcap=1.000000e-06 wacc=3.000000e-07 lacc=5.500000e-07 bden=1 prog=0 dyn=0
VM_pm_s4_vb_fix1v_s1g2 BLS_s4_vb_fix1v B_pm_s4_vb_fix1v_s1g2 0
X_pm_s4_vb_fix1v_s1g2 B_pm_s4_vb_fix1v_s1g2 WLON_s4_vb_fix1v PL VB_s4_vb_fix1v cell_candidate3_bd wcap=2.000000e-06 lcap=1.000000e-06 wacc=3.000000e-07 lacc=5.500000e-07 bden=1 prog=1 dyn=0 zrf=0
VM_pw_s4_vb_fix1v_s1g2 BLS_s4_vb_fix1v B_pw_s4_vb_fix1v_s1g2 0
X_pw_s4_vb_fix1v_s1g2 B_pw_s4_vb_fix1v_s1g2 WLON_s4_vb_fix1v PL VB_s4_vb_fix1v cell_candidate3_bd wcap=2.000000e-06 lcap=1.000000e-06 wacc=3.000000e-07 lacc=5.500000e-07 bden=1 prog=1 dyn=0 zrf={bd_zrf_wc}
VM_off_s4_vb_fix1v_s2g1_lo BLS_s4_vb_fix1v B_off_s4_vb_fix1v_s2g1_lo 0
X_off_s4_vb_fix1v_s2g1_lo B_off_s4_vb_fix1v_s2g1_lo WLLO PL VB_s4_vb_fix1v cell_candidate3_bd wcap=1.000000e-06 lcap=1.000000e-06 wacc=6.000000e-07 lacc=5.500000e-07 bden=1 prog=0 dyn=0
VM_off_s4_vb_fix1v_s2g1_mid BLS_s4_vb_fix1v B_off_s4_vb_fix1v_s2g1_mid 0
X_off_s4_vb_fix1v_s2g1_mid B_off_s4_vb_fix1v_s2g1_mid WLMID PL VB_s4_vb_fix1v cell_candidate3_bd wcap=1.000000e-06 lcap=1.000000e-06 wacc=6.000000e-07 lacc=5.500000e-07 bden=1 prog=0 dyn=0
VM_off_s4_vb_fix1v_s2g1_hi BLS_s4_vb_fix1v B_off_s4_vb_fix1v_s2g1_hi 0
X_off_s4_vb_fix1v_s2g1_hi B_off_s4_vb_fix1v_s2g1_hi WLHI PL VB_s4_vb_fix1v cell_candidate3_bd wcap=1.000000e-06 lcap=1.000000e-06 wacc=6.000000e-07 lacc=5.500000e-07 bden=1 prog=0 dyn=0
VM_offp_s4_vb_fix1v_s2g1_lo BLS_s4_vb_fix1v B_offp_s4_vb_fix1v_s2g1_lo 0
X_offp_s4_vb_fix1v_s2g1_lo B_offp_s4_vb_fix1v_s2g1_lo WLLO PL VB_s4_vb_fix1v cell_candidate3_bd wcap=1.000000e-06 lcap=1.000000e-06 wacc=6.000000e-07 lacc=5.500000e-07 bden=1 prog=1 dyn=0 zrf=0
VM_offp_s4_vb_fix1v_s2g1_mid BLS_s4_vb_fix1v B_offp_s4_vb_fix1v_s2g1_mid 0
X_offp_s4_vb_fix1v_s2g1_mid B_offp_s4_vb_fix1v_s2g1_mid WLMID PL VB_s4_vb_fix1v cell_candidate3_bd wcap=1.000000e-06 lcap=1.000000e-06 wacc=6.000000e-07 lacc=5.500000e-07 bden=1 prog=1 dyn=0 zrf=0
VM_offp_s4_vb_fix1v_s2g1_hi BLS_s4_vb_fix1v B_offp_s4_vb_fix1v_s2g1_hi 0
X_offp_s4_vb_fix1v_s2g1_hi B_offp_s4_vb_fix1v_s2g1_hi WLHI PL VB_s4_vb_fix1v cell_candidate3_bd wcap=1.000000e-06 lcap=1.000000e-06 wacc=6.000000e-07 lacc=5.500000e-07 bden=1 prog=1 dyn=0 zrf=0
VM_un_s4_vb_fix1v_s2g1 BLS_s4_vb_fix1v B_un_s4_vb_fix1v_s2g1 0
X_un_s4_vb_fix1v_s2g1 B_un_s4_vb_fix1v_s2g1 WLON_s4_vb_fix1v PL VB_s4_vb_fix1v cell_candidate3_bd wcap=1.000000e-06 lcap=1.000000e-06 wacc=6.000000e-07 lacc=5.500000e-07 bden=1 prog=0 dyn=0
VM_pm_s4_vb_fix1v_s2g1 BLS_s4_vb_fix1v B_pm_s4_vb_fix1v_s2g1 0
X_pm_s4_vb_fix1v_s2g1 B_pm_s4_vb_fix1v_s2g1 WLON_s4_vb_fix1v PL VB_s4_vb_fix1v cell_candidate3_bd wcap=1.000000e-06 lcap=1.000000e-06 wacc=6.000000e-07 lacc=5.500000e-07 bden=1 prog=1 dyn=0 zrf=0
VM_pw_s4_vb_fix1v_s2g1 BLS_s4_vb_fix1v B_pw_s4_vb_fix1v_s2g1 0
X_pw_s4_vb_fix1v_s2g1 B_pw_s4_vb_fix1v_s2g1 WLON_s4_vb_fix1v PL VB_s4_vb_fix1v cell_candidate3_bd wcap=1.000000e-06 lcap=1.000000e-06 wacc=6.000000e-07 lacc=5.500000e-07 bden=1 prog=1 dyn=0 zrf={bd_zrf_wc}
VM_off_s4_vb_fix1v_s2g2_lo BLS_s4_vb_fix1v B_off_s4_vb_fix1v_s2g2_lo 0
X_off_s4_vb_fix1v_s2g2_lo B_off_s4_vb_fix1v_s2g2_lo WLLO PL VB_s4_vb_fix1v cell_candidate3_bd wcap=2.000000e-06 lcap=1.000000e-06 wacc=6.000000e-07 lacc=5.500000e-07 bden=1 prog=0 dyn=0
VM_off_s4_vb_fix1v_s2g2_mid BLS_s4_vb_fix1v B_off_s4_vb_fix1v_s2g2_mid 0
X_off_s4_vb_fix1v_s2g2_mid B_off_s4_vb_fix1v_s2g2_mid WLMID PL VB_s4_vb_fix1v cell_candidate3_bd wcap=2.000000e-06 lcap=1.000000e-06 wacc=6.000000e-07 lacc=5.500000e-07 bden=1 prog=0 dyn=0
VM_off_s4_vb_fix1v_s2g2_hi BLS_s4_vb_fix1v B_off_s4_vb_fix1v_s2g2_hi 0
X_off_s4_vb_fix1v_s2g2_hi B_off_s4_vb_fix1v_s2g2_hi WLHI PL VB_s4_vb_fix1v cell_candidate3_bd wcap=2.000000e-06 lcap=1.000000e-06 wacc=6.000000e-07 lacc=5.500000e-07 bden=1 prog=0 dyn=0
VM_offp_s4_vb_fix1v_s2g2_lo BLS_s4_vb_fix1v B_offp_s4_vb_fix1v_s2g2_lo 0
X_offp_s4_vb_fix1v_s2g2_lo B_offp_s4_vb_fix1v_s2g2_lo WLLO PL VB_s4_vb_fix1v cell_candidate3_bd wcap=2.000000e-06 lcap=1.000000e-06 wacc=6.000000e-07 lacc=5.500000e-07 bden=1 prog=1 dyn=0 zrf=0
VM_offp_s4_vb_fix1v_s2g2_mid BLS_s4_vb_fix1v B_offp_s4_vb_fix1v_s2g2_mid 0
X_offp_s4_vb_fix1v_s2g2_mid B_offp_s4_vb_fix1v_s2g2_mid WLMID PL VB_s4_vb_fix1v cell_candidate3_bd wcap=2.000000e-06 lcap=1.000000e-06 wacc=6.000000e-07 lacc=5.500000e-07 bden=1 prog=1 dyn=0 zrf=0
VM_offp_s4_vb_fix1v_s2g2_hi BLS_s4_vb_fix1v B_offp_s4_vb_fix1v_s2g2_hi 0
X_offp_s4_vb_fix1v_s2g2_hi B_offp_s4_vb_fix1v_s2g2_hi WLHI PL VB_s4_vb_fix1v cell_candidate3_bd wcap=2.000000e-06 lcap=1.000000e-06 wacc=6.000000e-07 lacc=5.500000e-07 bden=1 prog=1 dyn=0 zrf=0
VM_un_s4_vb_fix1v_s2g2 BLS_s4_vb_fix1v B_un_s4_vb_fix1v_s2g2 0
X_un_s4_vb_fix1v_s2g2 B_un_s4_vb_fix1v_s2g2 WLON_s4_vb_fix1v PL VB_s4_vb_fix1v cell_candidate3_bd wcap=2.000000e-06 lcap=1.000000e-06 wacc=6.000000e-07 lacc=5.500000e-07 bden=1 prog=0 dyn=0
VM_pm_s4_vb_fix1v_s2g2 BLS_s4_vb_fix1v B_pm_s4_vb_fix1v_s2g2 0
X_pm_s4_vb_fix1v_s2g2 B_pm_s4_vb_fix1v_s2g2 WLON_s4_vb_fix1v PL VB_s4_vb_fix1v cell_candidate3_bd wcap=2.000000e-06 lcap=1.000000e-06 wacc=6.000000e-07 lacc=5.500000e-07 bden=1 prog=1 dyn=0 zrf=0
VM_pw_s4_vb_fix1v_s2g2 BLS_s4_vb_fix1v B_pw_s4_vb_fix1v_s2g2 0
X_pw_s4_vb_fix1v_s2g2 B_pw_s4_vb_fix1v_s2g2 WLON_s4_vb_fix1v PL VB_s4_vb_fix1v cell_candidate3_bd wcap=2.000000e-06 lcap=1.000000e-06 wacc=6.000000e-07 lacc=5.500000e-07 bden=1 prog=1 dyn=0 zrf={bd_zrf_wc}
EBL_s5_rail1v8 BLS_s5_rail1v8 0 BL 0 1.800000e+00
VVB_s5_rail1v8 VB_s5_rail1v8 0 DC 3.300000e+00
VWLON_s5_rail1v8 WLON_s5_rail1v8 0 DC 0.000000e+00
VM_off_s5_rail1v8_s1g1_lo BLS_s5_rail1v8 B_off_s5_rail1v8_s1g1_lo 0
X_off_s5_rail1v8_s1g1_lo B_off_s5_rail1v8_s1g1_lo WLLO PL VB_s5_rail1v8 cell_candidate3_bd wcap=1.000000e-06 lcap=1.000000e-06 wacc=3.000000e-07 lacc=5.500000e-07 bden=1 prog=0 dyn=0
VM_off_s5_rail1v8_s1g1_mid BLS_s5_rail1v8 B_off_s5_rail1v8_s1g1_mid 0
X_off_s5_rail1v8_s1g1_mid B_off_s5_rail1v8_s1g1_mid WLMID PL VB_s5_rail1v8 cell_candidate3_bd wcap=1.000000e-06 lcap=1.000000e-06 wacc=3.000000e-07 lacc=5.500000e-07 bden=1 prog=0 dyn=0
VM_off_s5_rail1v8_s1g1_hi BLS_s5_rail1v8 B_off_s5_rail1v8_s1g1_hi 0
X_off_s5_rail1v8_s1g1_hi B_off_s5_rail1v8_s1g1_hi WLHI PL VB_s5_rail1v8 cell_candidate3_bd wcap=1.000000e-06 lcap=1.000000e-06 wacc=3.000000e-07 lacc=5.500000e-07 bden=1 prog=0 dyn=0
VM_offp_s5_rail1v8_s1g1_lo BLS_s5_rail1v8 B_offp_s5_rail1v8_s1g1_lo 0
X_offp_s5_rail1v8_s1g1_lo B_offp_s5_rail1v8_s1g1_lo WLLO PL VB_s5_rail1v8 cell_candidate3_bd wcap=1.000000e-06 lcap=1.000000e-06 wacc=3.000000e-07 lacc=5.500000e-07 bden=1 prog=1 dyn=0 zrf=0
VM_offp_s5_rail1v8_s1g1_mid BLS_s5_rail1v8 B_offp_s5_rail1v8_s1g1_mid 0
X_offp_s5_rail1v8_s1g1_mid B_offp_s5_rail1v8_s1g1_mid WLMID PL VB_s5_rail1v8 cell_candidate3_bd wcap=1.000000e-06 lcap=1.000000e-06 wacc=3.000000e-07 lacc=5.500000e-07 bden=1 prog=1 dyn=0 zrf=0
VM_offp_s5_rail1v8_s1g1_hi BLS_s5_rail1v8 B_offp_s5_rail1v8_s1g1_hi 0
X_offp_s5_rail1v8_s1g1_hi B_offp_s5_rail1v8_s1g1_hi WLHI PL VB_s5_rail1v8 cell_candidate3_bd wcap=1.000000e-06 lcap=1.000000e-06 wacc=3.000000e-07 lacc=5.500000e-07 bden=1 prog=1 dyn=0 zrf=0
VM_un_s5_rail1v8_s1g1 BLS_s5_rail1v8 B_un_s5_rail1v8_s1g1 0
X_un_s5_rail1v8_s1g1 B_un_s5_rail1v8_s1g1 WLON_s5_rail1v8 PL VB_s5_rail1v8 cell_candidate3_bd wcap=1.000000e-06 lcap=1.000000e-06 wacc=3.000000e-07 lacc=5.500000e-07 bden=1 prog=0 dyn=0
VM_pm_s5_rail1v8_s1g1 BLS_s5_rail1v8 B_pm_s5_rail1v8_s1g1 0
X_pm_s5_rail1v8_s1g1 B_pm_s5_rail1v8_s1g1 WLON_s5_rail1v8 PL VB_s5_rail1v8 cell_candidate3_bd wcap=1.000000e-06 lcap=1.000000e-06 wacc=3.000000e-07 lacc=5.500000e-07 bden=1 prog=1 dyn=0 zrf=0
VM_pw_s5_rail1v8_s1g1 BLS_s5_rail1v8 B_pw_s5_rail1v8_s1g1 0
X_pw_s5_rail1v8_s1g1 B_pw_s5_rail1v8_s1g1 WLON_s5_rail1v8 PL VB_s5_rail1v8 cell_candidate3_bd wcap=1.000000e-06 lcap=1.000000e-06 wacc=3.000000e-07 lacc=5.500000e-07 bden=1 prog=1 dyn=0 zrf={bd_zrf_wc}
VM_off_s5_rail1v8_s1g2_lo BLS_s5_rail1v8 B_off_s5_rail1v8_s1g2_lo 0
X_off_s5_rail1v8_s1g2_lo B_off_s5_rail1v8_s1g2_lo WLLO PL VB_s5_rail1v8 cell_candidate3_bd wcap=2.000000e-06 lcap=1.000000e-06 wacc=3.000000e-07 lacc=5.500000e-07 bden=1 prog=0 dyn=0
VM_off_s5_rail1v8_s1g2_mid BLS_s5_rail1v8 B_off_s5_rail1v8_s1g2_mid 0
X_off_s5_rail1v8_s1g2_mid B_off_s5_rail1v8_s1g2_mid WLMID PL VB_s5_rail1v8 cell_candidate3_bd wcap=2.000000e-06 lcap=1.000000e-06 wacc=3.000000e-07 lacc=5.500000e-07 bden=1 prog=0 dyn=0
VM_off_s5_rail1v8_s1g2_hi BLS_s5_rail1v8 B_off_s5_rail1v8_s1g2_hi 0
X_off_s5_rail1v8_s1g2_hi B_off_s5_rail1v8_s1g2_hi WLHI PL VB_s5_rail1v8 cell_candidate3_bd wcap=2.000000e-06 lcap=1.000000e-06 wacc=3.000000e-07 lacc=5.500000e-07 bden=1 prog=0 dyn=0
VM_offp_s5_rail1v8_s1g2_lo BLS_s5_rail1v8 B_offp_s5_rail1v8_s1g2_lo 0
X_offp_s5_rail1v8_s1g2_lo B_offp_s5_rail1v8_s1g2_lo WLLO PL VB_s5_rail1v8 cell_candidate3_bd wcap=2.000000e-06 lcap=1.000000e-06 wacc=3.000000e-07 lacc=5.500000e-07 bden=1 prog=1 dyn=0 zrf=0
VM_offp_s5_rail1v8_s1g2_mid BLS_s5_rail1v8 B_offp_s5_rail1v8_s1g2_mid 0
X_offp_s5_rail1v8_s1g2_mid B_offp_s5_rail1v8_s1g2_mid WLMID PL VB_s5_rail1v8 cell_candidate3_bd wcap=2.000000e-06 lcap=1.000000e-06 wacc=3.000000e-07 lacc=5.500000e-07 bden=1 prog=1 dyn=0 zrf=0
VM_offp_s5_rail1v8_s1g2_hi BLS_s5_rail1v8 B_offp_s5_rail1v8_s1g2_hi 0
X_offp_s5_rail1v8_s1g2_hi B_offp_s5_rail1v8_s1g2_hi WLHI PL VB_s5_rail1v8 cell_candidate3_bd wcap=2.000000e-06 lcap=1.000000e-06 wacc=3.000000e-07 lacc=5.500000e-07 bden=1 prog=1 dyn=0 zrf=0
VM_un_s5_rail1v8_s1g2 BLS_s5_rail1v8 B_un_s5_rail1v8_s1g2 0
X_un_s5_rail1v8_s1g2 B_un_s5_rail1v8_s1g2 WLON_s5_rail1v8 PL VB_s5_rail1v8 cell_candidate3_bd wcap=2.000000e-06 lcap=1.000000e-06 wacc=3.000000e-07 lacc=5.500000e-07 bden=1 prog=0 dyn=0
VM_pm_s5_rail1v8_s1g2 BLS_s5_rail1v8 B_pm_s5_rail1v8_s1g2 0
X_pm_s5_rail1v8_s1g2 B_pm_s5_rail1v8_s1g2 WLON_s5_rail1v8 PL VB_s5_rail1v8 cell_candidate3_bd wcap=2.000000e-06 lcap=1.000000e-06 wacc=3.000000e-07 lacc=5.500000e-07 bden=1 prog=1 dyn=0 zrf=0
VM_pw_s5_rail1v8_s1g2 BLS_s5_rail1v8 B_pw_s5_rail1v8_s1g2 0
X_pw_s5_rail1v8_s1g2 B_pw_s5_rail1v8_s1g2 WLON_s5_rail1v8 PL VB_s5_rail1v8 cell_candidate3_bd wcap=2.000000e-06 lcap=1.000000e-06 wacc=3.000000e-07 lacc=5.500000e-07 bden=1 prog=1 dyn=0 zrf={bd_zrf_wc}
VM_off_s5_rail1v8_s2g1_lo BLS_s5_rail1v8 B_off_s5_rail1v8_s2g1_lo 0
X_off_s5_rail1v8_s2g1_lo B_off_s5_rail1v8_s2g1_lo WLLO PL VB_s5_rail1v8 cell_candidate3_bd wcap=1.000000e-06 lcap=1.000000e-06 wacc=6.000000e-07 lacc=5.500000e-07 bden=1 prog=0 dyn=0
VM_off_s5_rail1v8_s2g1_mid BLS_s5_rail1v8 B_off_s5_rail1v8_s2g1_mid 0
X_off_s5_rail1v8_s2g1_mid B_off_s5_rail1v8_s2g1_mid WLMID PL VB_s5_rail1v8 cell_candidate3_bd wcap=1.000000e-06 lcap=1.000000e-06 wacc=6.000000e-07 lacc=5.500000e-07 bden=1 prog=0 dyn=0
VM_off_s5_rail1v8_s2g1_hi BLS_s5_rail1v8 B_off_s5_rail1v8_s2g1_hi 0
X_off_s5_rail1v8_s2g1_hi B_off_s5_rail1v8_s2g1_hi WLHI PL VB_s5_rail1v8 cell_candidate3_bd wcap=1.000000e-06 lcap=1.000000e-06 wacc=6.000000e-07 lacc=5.500000e-07 bden=1 prog=0 dyn=0
VM_offp_s5_rail1v8_s2g1_lo BLS_s5_rail1v8 B_offp_s5_rail1v8_s2g1_lo 0
X_offp_s5_rail1v8_s2g1_lo B_offp_s5_rail1v8_s2g1_lo WLLO PL VB_s5_rail1v8 cell_candidate3_bd wcap=1.000000e-06 lcap=1.000000e-06 wacc=6.000000e-07 lacc=5.500000e-07 bden=1 prog=1 dyn=0 zrf=0
VM_offp_s5_rail1v8_s2g1_mid BLS_s5_rail1v8 B_offp_s5_rail1v8_s2g1_mid 0
X_offp_s5_rail1v8_s2g1_mid B_offp_s5_rail1v8_s2g1_mid WLMID PL VB_s5_rail1v8 cell_candidate3_bd wcap=1.000000e-06 lcap=1.000000e-06 wacc=6.000000e-07 lacc=5.500000e-07 bden=1 prog=1 dyn=0 zrf=0
VM_offp_s5_rail1v8_s2g1_hi BLS_s5_rail1v8 B_offp_s5_rail1v8_s2g1_hi 0
X_offp_s5_rail1v8_s2g1_hi B_offp_s5_rail1v8_s2g1_hi WLHI PL VB_s5_rail1v8 cell_candidate3_bd wcap=1.000000e-06 lcap=1.000000e-06 wacc=6.000000e-07 lacc=5.500000e-07 bden=1 prog=1 dyn=0 zrf=0
VM_un_s5_rail1v8_s2g1 BLS_s5_rail1v8 B_un_s5_rail1v8_s2g1 0
X_un_s5_rail1v8_s2g1 B_un_s5_rail1v8_s2g1 WLON_s5_rail1v8 PL VB_s5_rail1v8 cell_candidate3_bd wcap=1.000000e-06 lcap=1.000000e-06 wacc=6.000000e-07 lacc=5.500000e-07 bden=1 prog=0 dyn=0
VM_pm_s5_rail1v8_s2g1 BLS_s5_rail1v8 B_pm_s5_rail1v8_s2g1 0
X_pm_s5_rail1v8_s2g1 B_pm_s5_rail1v8_s2g1 WLON_s5_rail1v8 PL VB_s5_rail1v8 cell_candidate3_bd wcap=1.000000e-06 lcap=1.000000e-06 wacc=6.000000e-07 lacc=5.500000e-07 bden=1 prog=1 dyn=0 zrf=0
VM_pw_s5_rail1v8_s2g1 BLS_s5_rail1v8 B_pw_s5_rail1v8_s2g1 0
X_pw_s5_rail1v8_s2g1 B_pw_s5_rail1v8_s2g1 WLON_s5_rail1v8 PL VB_s5_rail1v8 cell_candidate3_bd wcap=1.000000e-06 lcap=1.000000e-06 wacc=6.000000e-07 lacc=5.500000e-07 bden=1 prog=1 dyn=0 zrf={bd_zrf_wc}
VM_off_s5_rail1v8_s2g2_lo BLS_s5_rail1v8 B_off_s5_rail1v8_s2g2_lo 0
X_off_s5_rail1v8_s2g2_lo B_off_s5_rail1v8_s2g2_lo WLLO PL VB_s5_rail1v8 cell_candidate3_bd wcap=2.000000e-06 lcap=1.000000e-06 wacc=6.000000e-07 lacc=5.500000e-07 bden=1 prog=0 dyn=0
VM_off_s5_rail1v8_s2g2_mid BLS_s5_rail1v8 B_off_s5_rail1v8_s2g2_mid 0
X_off_s5_rail1v8_s2g2_mid B_off_s5_rail1v8_s2g2_mid WLMID PL VB_s5_rail1v8 cell_candidate3_bd wcap=2.000000e-06 lcap=1.000000e-06 wacc=6.000000e-07 lacc=5.500000e-07 bden=1 prog=0 dyn=0
VM_off_s5_rail1v8_s2g2_hi BLS_s5_rail1v8 B_off_s5_rail1v8_s2g2_hi 0
X_off_s5_rail1v8_s2g2_hi B_off_s5_rail1v8_s2g2_hi WLHI PL VB_s5_rail1v8 cell_candidate3_bd wcap=2.000000e-06 lcap=1.000000e-06 wacc=6.000000e-07 lacc=5.500000e-07 bden=1 prog=0 dyn=0
VM_offp_s5_rail1v8_s2g2_lo BLS_s5_rail1v8 B_offp_s5_rail1v8_s2g2_lo 0
X_offp_s5_rail1v8_s2g2_lo B_offp_s5_rail1v8_s2g2_lo WLLO PL VB_s5_rail1v8 cell_candidate3_bd wcap=2.000000e-06 lcap=1.000000e-06 wacc=6.000000e-07 lacc=5.500000e-07 bden=1 prog=1 dyn=0 zrf=0
VM_offp_s5_rail1v8_s2g2_mid BLS_s5_rail1v8 B_offp_s5_rail1v8_s2g2_mid 0
X_offp_s5_rail1v8_s2g2_mid B_offp_s5_rail1v8_s2g2_mid WLMID PL VB_s5_rail1v8 cell_candidate3_bd wcap=2.000000e-06 lcap=1.000000e-06 wacc=6.000000e-07 lacc=5.500000e-07 bden=1 prog=1 dyn=0 zrf=0
VM_offp_s5_rail1v8_s2g2_hi BLS_s5_rail1v8 B_offp_s5_rail1v8_s2g2_hi 0
X_offp_s5_rail1v8_s2g2_hi B_offp_s5_rail1v8_s2g2_hi WLHI PL VB_s5_rail1v8 cell_candidate3_bd wcap=2.000000e-06 lcap=1.000000e-06 wacc=6.000000e-07 lacc=5.500000e-07 bden=1 prog=1 dyn=0 zrf=0
VM_un_s5_rail1v8_s2g2 BLS_s5_rail1v8 B_un_s5_rail1v8_s2g2 0
X_un_s5_rail1v8_s2g2 B_un_s5_rail1v8_s2g2 WLON_s5_rail1v8 PL VB_s5_rail1v8 cell_candidate3_bd wcap=2.000000e-06 lcap=1.000000e-06 wacc=6.000000e-07 lacc=5.500000e-07 bden=1 prog=0 dyn=0
VM_pm_s5_rail1v8_s2g2 BLS_s5_rail1v8 B_pm_s5_rail1v8_s2g2 0
X_pm_s5_rail1v8_s2g2 B_pm_s5_rail1v8_s2g2 WLON_s5_rail1v8 PL VB_s5_rail1v8 cell_candidate3_bd wcap=2.000000e-06 lcap=1.000000e-06 wacc=6.000000e-07 lacc=5.500000e-07 bden=1 prog=1 dyn=0 zrf=0
VM_pw_s5_rail1v8_s2g2 BLS_s5_rail1v8 B_pw_s5_rail1v8_s2g2 0
X_pw_s5_rail1v8_s2g2 B_pw_s5_rail1v8_s2g2 WLON_s5_rail1v8 PL VB_s5_rail1v8 cell_candidate3_bd wcap=2.000000e-06 lcap=1.000000e-06 wacc=6.000000e-07 lacc=5.500000e-07 bden=1 prog=1 dyn=0 zrf={bd_zrf_wc}
EBL_s6_rail1v8_vb_track BLS_s6_rail1v8_vb_track 0 BL 0 1.800000e+00
BVB_s6_rail1v8_vb_track VB_s6_rail1v8_vb_track 0 V = 'v(bls_s6_rail1v8_vb_track) + 0.000000e+00'
VWLON_s6_rail1v8_vb_track WLON_s6_rail1v8_vb_track 0 DC 0.000000e+00
VM_off_s6_rail1v8_vb_track_s1g1_lo BLS_s6_rail1v8_vb_track B_off_s6_rail1v8_vb_track_s1g1_lo 0
X_off_s6_rail1v8_vb_track_s1g1_lo B_off_s6_rail1v8_vb_track_s1g1_lo WLLO PL VB_s6_rail1v8_vb_track cell_candidate3_bd wcap=1.000000e-06 lcap=1.000000e-06 wacc=3.000000e-07 lacc=5.500000e-07 bden=1 prog=0 dyn=0
VM_off_s6_rail1v8_vb_track_s1g1_mid BLS_s6_rail1v8_vb_track B_off_s6_rail1v8_vb_track_s1g1_mid 0
X_off_s6_rail1v8_vb_track_s1g1_mid B_off_s6_rail1v8_vb_track_s1g1_mid WLMID PL VB_s6_rail1v8_vb_track cell_candidate3_bd wcap=1.000000e-06 lcap=1.000000e-06 wacc=3.000000e-07 lacc=5.500000e-07 bden=1 prog=0 dyn=0
VM_off_s6_rail1v8_vb_track_s1g1_hi BLS_s6_rail1v8_vb_track B_off_s6_rail1v8_vb_track_s1g1_hi 0
X_off_s6_rail1v8_vb_track_s1g1_hi B_off_s6_rail1v8_vb_track_s1g1_hi WLHI PL VB_s6_rail1v8_vb_track cell_candidate3_bd wcap=1.000000e-06 lcap=1.000000e-06 wacc=3.000000e-07 lacc=5.500000e-07 bden=1 prog=0 dyn=0
VM_offp_s6_rail1v8_vb_track_s1g1_lo BLS_s6_rail1v8_vb_track B_offp_s6_rail1v8_vb_track_s1g1_lo 0
X_offp_s6_rail1v8_vb_track_s1g1_lo B_offp_s6_rail1v8_vb_track_s1g1_lo WLLO PL VB_s6_rail1v8_vb_track cell_candidate3_bd wcap=1.000000e-06 lcap=1.000000e-06 wacc=3.000000e-07 lacc=5.500000e-07 bden=1 prog=1 dyn=0 zrf=0
VM_offp_s6_rail1v8_vb_track_s1g1_mid BLS_s6_rail1v8_vb_track B_offp_s6_rail1v8_vb_track_s1g1_mid 0
X_offp_s6_rail1v8_vb_track_s1g1_mid B_offp_s6_rail1v8_vb_track_s1g1_mid WLMID PL VB_s6_rail1v8_vb_track cell_candidate3_bd wcap=1.000000e-06 lcap=1.000000e-06 wacc=3.000000e-07 lacc=5.500000e-07 bden=1 prog=1 dyn=0 zrf=0
VM_offp_s6_rail1v8_vb_track_s1g1_hi BLS_s6_rail1v8_vb_track B_offp_s6_rail1v8_vb_track_s1g1_hi 0
X_offp_s6_rail1v8_vb_track_s1g1_hi B_offp_s6_rail1v8_vb_track_s1g1_hi WLHI PL VB_s6_rail1v8_vb_track cell_candidate3_bd wcap=1.000000e-06 lcap=1.000000e-06 wacc=3.000000e-07 lacc=5.500000e-07 bden=1 prog=1 dyn=0 zrf=0
VM_un_s6_rail1v8_vb_track_s1g1 BLS_s6_rail1v8_vb_track B_un_s6_rail1v8_vb_track_s1g1 0
X_un_s6_rail1v8_vb_track_s1g1 B_un_s6_rail1v8_vb_track_s1g1 WLON_s6_rail1v8_vb_track PL VB_s6_rail1v8_vb_track cell_candidate3_bd wcap=1.000000e-06 lcap=1.000000e-06 wacc=3.000000e-07 lacc=5.500000e-07 bden=1 prog=0 dyn=0
VM_pm_s6_rail1v8_vb_track_s1g1 BLS_s6_rail1v8_vb_track B_pm_s6_rail1v8_vb_track_s1g1 0
X_pm_s6_rail1v8_vb_track_s1g1 B_pm_s6_rail1v8_vb_track_s1g1 WLON_s6_rail1v8_vb_track PL VB_s6_rail1v8_vb_track cell_candidate3_bd wcap=1.000000e-06 lcap=1.000000e-06 wacc=3.000000e-07 lacc=5.500000e-07 bden=1 prog=1 dyn=0 zrf=0
VM_pw_s6_rail1v8_vb_track_s1g1 BLS_s6_rail1v8_vb_track B_pw_s6_rail1v8_vb_track_s1g1 0
X_pw_s6_rail1v8_vb_track_s1g1 B_pw_s6_rail1v8_vb_track_s1g1 WLON_s6_rail1v8_vb_track PL VB_s6_rail1v8_vb_track cell_candidate3_bd wcap=1.000000e-06 lcap=1.000000e-06 wacc=3.000000e-07 lacc=5.500000e-07 bden=1 prog=1 dyn=0 zrf={bd_zrf_wc}
VM_off_s6_rail1v8_vb_track_s1g2_lo BLS_s6_rail1v8_vb_track B_off_s6_rail1v8_vb_track_s1g2_lo 0
X_off_s6_rail1v8_vb_track_s1g2_lo B_off_s6_rail1v8_vb_track_s1g2_lo WLLO PL VB_s6_rail1v8_vb_track cell_candidate3_bd wcap=2.000000e-06 lcap=1.000000e-06 wacc=3.000000e-07 lacc=5.500000e-07 bden=1 prog=0 dyn=0
VM_off_s6_rail1v8_vb_track_s1g2_mid BLS_s6_rail1v8_vb_track B_off_s6_rail1v8_vb_track_s1g2_mid 0
X_off_s6_rail1v8_vb_track_s1g2_mid B_off_s6_rail1v8_vb_track_s1g2_mid WLMID PL VB_s6_rail1v8_vb_track cell_candidate3_bd wcap=2.000000e-06 lcap=1.000000e-06 wacc=3.000000e-07 lacc=5.500000e-07 bden=1 prog=0 dyn=0
VM_off_s6_rail1v8_vb_track_s1g2_hi BLS_s6_rail1v8_vb_track B_off_s6_rail1v8_vb_track_s1g2_hi 0
X_off_s6_rail1v8_vb_track_s1g2_hi B_off_s6_rail1v8_vb_track_s1g2_hi WLHI PL VB_s6_rail1v8_vb_track cell_candidate3_bd wcap=2.000000e-06 lcap=1.000000e-06 wacc=3.000000e-07 lacc=5.500000e-07 bden=1 prog=0 dyn=0
VM_offp_s6_rail1v8_vb_track_s1g2_lo BLS_s6_rail1v8_vb_track B_offp_s6_rail1v8_vb_track_s1g2_lo 0
X_offp_s6_rail1v8_vb_track_s1g2_lo B_offp_s6_rail1v8_vb_track_s1g2_lo WLLO PL VB_s6_rail1v8_vb_track cell_candidate3_bd wcap=2.000000e-06 lcap=1.000000e-06 wacc=3.000000e-07 lacc=5.500000e-07 bden=1 prog=1 dyn=0 zrf=0
VM_offp_s6_rail1v8_vb_track_s1g2_mid BLS_s6_rail1v8_vb_track B_offp_s6_rail1v8_vb_track_s1g2_mid 0
X_offp_s6_rail1v8_vb_track_s1g2_mid B_offp_s6_rail1v8_vb_track_s1g2_mid WLMID PL VB_s6_rail1v8_vb_track cell_candidate3_bd wcap=2.000000e-06 lcap=1.000000e-06 wacc=3.000000e-07 lacc=5.500000e-07 bden=1 prog=1 dyn=0 zrf=0
VM_offp_s6_rail1v8_vb_track_s1g2_hi BLS_s6_rail1v8_vb_track B_offp_s6_rail1v8_vb_track_s1g2_hi 0
X_offp_s6_rail1v8_vb_track_s1g2_hi B_offp_s6_rail1v8_vb_track_s1g2_hi WLHI PL VB_s6_rail1v8_vb_track cell_candidate3_bd wcap=2.000000e-06 lcap=1.000000e-06 wacc=3.000000e-07 lacc=5.500000e-07 bden=1 prog=1 dyn=0 zrf=0
VM_un_s6_rail1v8_vb_track_s1g2 BLS_s6_rail1v8_vb_track B_un_s6_rail1v8_vb_track_s1g2 0
X_un_s6_rail1v8_vb_track_s1g2 B_un_s6_rail1v8_vb_track_s1g2 WLON_s6_rail1v8_vb_track PL VB_s6_rail1v8_vb_track cell_candidate3_bd wcap=2.000000e-06 lcap=1.000000e-06 wacc=3.000000e-07 lacc=5.500000e-07 bden=1 prog=0 dyn=0
VM_pm_s6_rail1v8_vb_track_s1g2 BLS_s6_rail1v8_vb_track B_pm_s6_rail1v8_vb_track_s1g2 0
X_pm_s6_rail1v8_vb_track_s1g2 B_pm_s6_rail1v8_vb_track_s1g2 WLON_s6_rail1v8_vb_track PL VB_s6_rail1v8_vb_track cell_candidate3_bd wcap=2.000000e-06 lcap=1.000000e-06 wacc=3.000000e-07 lacc=5.500000e-07 bden=1 prog=1 dyn=0 zrf=0
VM_pw_s6_rail1v8_vb_track_s1g2 BLS_s6_rail1v8_vb_track B_pw_s6_rail1v8_vb_track_s1g2 0
X_pw_s6_rail1v8_vb_track_s1g2 B_pw_s6_rail1v8_vb_track_s1g2 WLON_s6_rail1v8_vb_track PL VB_s6_rail1v8_vb_track cell_candidate3_bd wcap=2.000000e-06 lcap=1.000000e-06 wacc=3.000000e-07 lacc=5.500000e-07 bden=1 prog=1 dyn=0 zrf={bd_zrf_wc}
VM_off_s6_rail1v8_vb_track_s2g1_lo BLS_s6_rail1v8_vb_track B_off_s6_rail1v8_vb_track_s2g1_lo 0
X_off_s6_rail1v8_vb_track_s2g1_lo B_off_s6_rail1v8_vb_track_s2g1_lo WLLO PL VB_s6_rail1v8_vb_track cell_candidate3_bd wcap=1.000000e-06 lcap=1.000000e-06 wacc=6.000000e-07 lacc=5.500000e-07 bden=1 prog=0 dyn=0
VM_off_s6_rail1v8_vb_track_s2g1_mid BLS_s6_rail1v8_vb_track B_off_s6_rail1v8_vb_track_s2g1_mid 0
X_off_s6_rail1v8_vb_track_s2g1_mid B_off_s6_rail1v8_vb_track_s2g1_mid WLMID PL VB_s6_rail1v8_vb_track cell_candidate3_bd wcap=1.000000e-06 lcap=1.000000e-06 wacc=6.000000e-07 lacc=5.500000e-07 bden=1 prog=0 dyn=0
VM_off_s6_rail1v8_vb_track_s2g1_hi BLS_s6_rail1v8_vb_track B_off_s6_rail1v8_vb_track_s2g1_hi 0
X_off_s6_rail1v8_vb_track_s2g1_hi B_off_s6_rail1v8_vb_track_s2g1_hi WLHI PL VB_s6_rail1v8_vb_track cell_candidate3_bd wcap=1.000000e-06 lcap=1.000000e-06 wacc=6.000000e-07 lacc=5.500000e-07 bden=1 prog=0 dyn=0
VM_offp_s6_rail1v8_vb_track_s2g1_lo BLS_s6_rail1v8_vb_track B_offp_s6_rail1v8_vb_track_s2g1_lo 0
X_offp_s6_rail1v8_vb_track_s2g1_lo B_offp_s6_rail1v8_vb_track_s2g1_lo WLLO PL VB_s6_rail1v8_vb_track cell_candidate3_bd wcap=1.000000e-06 lcap=1.000000e-06 wacc=6.000000e-07 lacc=5.500000e-07 bden=1 prog=1 dyn=0 zrf=0
VM_offp_s6_rail1v8_vb_track_s2g1_mid BLS_s6_rail1v8_vb_track B_offp_s6_rail1v8_vb_track_s2g1_mid 0
X_offp_s6_rail1v8_vb_track_s2g1_mid B_offp_s6_rail1v8_vb_track_s2g1_mid WLMID PL VB_s6_rail1v8_vb_track cell_candidate3_bd wcap=1.000000e-06 lcap=1.000000e-06 wacc=6.000000e-07 lacc=5.500000e-07 bden=1 prog=1 dyn=0 zrf=0
VM_offp_s6_rail1v8_vb_track_s2g1_hi BLS_s6_rail1v8_vb_track B_offp_s6_rail1v8_vb_track_s2g1_hi 0
X_offp_s6_rail1v8_vb_track_s2g1_hi B_offp_s6_rail1v8_vb_track_s2g1_hi WLHI PL VB_s6_rail1v8_vb_track cell_candidate3_bd wcap=1.000000e-06 lcap=1.000000e-06 wacc=6.000000e-07 lacc=5.500000e-07 bden=1 prog=1 dyn=0 zrf=0
VM_un_s6_rail1v8_vb_track_s2g1 BLS_s6_rail1v8_vb_track B_un_s6_rail1v8_vb_track_s2g1 0
X_un_s6_rail1v8_vb_track_s2g1 B_un_s6_rail1v8_vb_track_s2g1 WLON_s6_rail1v8_vb_track PL VB_s6_rail1v8_vb_track cell_candidate3_bd wcap=1.000000e-06 lcap=1.000000e-06 wacc=6.000000e-07 lacc=5.500000e-07 bden=1 prog=0 dyn=0
VM_pm_s6_rail1v8_vb_track_s2g1 BLS_s6_rail1v8_vb_track B_pm_s6_rail1v8_vb_track_s2g1 0
X_pm_s6_rail1v8_vb_track_s2g1 B_pm_s6_rail1v8_vb_track_s2g1 WLON_s6_rail1v8_vb_track PL VB_s6_rail1v8_vb_track cell_candidate3_bd wcap=1.000000e-06 lcap=1.000000e-06 wacc=6.000000e-07 lacc=5.500000e-07 bden=1 prog=1 dyn=0 zrf=0
VM_pw_s6_rail1v8_vb_track_s2g1 BLS_s6_rail1v8_vb_track B_pw_s6_rail1v8_vb_track_s2g1 0
X_pw_s6_rail1v8_vb_track_s2g1 B_pw_s6_rail1v8_vb_track_s2g1 WLON_s6_rail1v8_vb_track PL VB_s6_rail1v8_vb_track cell_candidate3_bd wcap=1.000000e-06 lcap=1.000000e-06 wacc=6.000000e-07 lacc=5.500000e-07 bden=1 prog=1 dyn=0 zrf={bd_zrf_wc}
VM_off_s6_rail1v8_vb_track_s2g2_lo BLS_s6_rail1v8_vb_track B_off_s6_rail1v8_vb_track_s2g2_lo 0
X_off_s6_rail1v8_vb_track_s2g2_lo B_off_s6_rail1v8_vb_track_s2g2_lo WLLO PL VB_s6_rail1v8_vb_track cell_candidate3_bd wcap=2.000000e-06 lcap=1.000000e-06 wacc=6.000000e-07 lacc=5.500000e-07 bden=1 prog=0 dyn=0
VM_off_s6_rail1v8_vb_track_s2g2_mid BLS_s6_rail1v8_vb_track B_off_s6_rail1v8_vb_track_s2g2_mid 0
X_off_s6_rail1v8_vb_track_s2g2_mid B_off_s6_rail1v8_vb_track_s2g2_mid WLMID PL VB_s6_rail1v8_vb_track cell_candidate3_bd wcap=2.000000e-06 lcap=1.000000e-06 wacc=6.000000e-07 lacc=5.500000e-07 bden=1 prog=0 dyn=0
VM_off_s6_rail1v8_vb_track_s2g2_hi BLS_s6_rail1v8_vb_track B_off_s6_rail1v8_vb_track_s2g2_hi 0
X_off_s6_rail1v8_vb_track_s2g2_hi B_off_s6_rail1v8_vb_track_s2g2_hi WLHI PL VB_s6_rail1v8_vb_track cell_candidate3_bd wcap=2.000000e-06 lcap=1.000000e-06 wacc=6.000000e-07 lacc=5.500000e-07 bden=1 prog=0 dyn=0
VM_offp_s6_rail1v8_vb_track_s2g2_lo BLS_s6_rail1v8_vb_track B_offp_s6_rail1v8_vb_track_s2g2_lo 0
X_offp_s6_rail1v8_vb_track_s2g2_lo B_offp_s6_rail1v8_vb_track_s2g2_lo WLLO PL VB_s6_rail1v8_vb_track cell_candidate3_bd wcap=2.000000e-06 lcap=1.000000e-06 wacc=6.000000e-07 lacc=5.500000e-07 bden=1 prog=1 dyn=0 zrf=0
VM_offp_s6_rail1v8_vb_track_s2g2_mid BLS_s6_rail1v8_vb_track B_offp_s6_rail1v8_vb_track_s2g2_mid 0
X_offp_s6_rail1v8_vb_track_s2g2_mid B_offp_s6_rail1v8_vb_track_s2g2_mid WLMID PL VB_s6_rail1v8_vb_track cell_candidate3_bd wcap=2.000000e-06 lcap=1.000000e-06 wacc=6.000000e-07 lacc=5.500000e-07 bden=1 prog=1 dyn=0 zrf=0
VM_offp_s6_rail1v8_vb_track_s2g2_hi BLS_s6_rail1v8_vb_track B_offp_s6_rail1v8_vb_track_s2g2_hi 0
X_offp_s6_rail1v8_vb_track_s2g2_hi B_offp_s6_rail1v8_vb_track_s2g2_hi WLHI PL VB_s6_rail1v8_vb_track cell_candidate3_bd wcap=2.000000e-06 lcap=1.000000e-06 wacc=6.000000e-07 lacc=5.500000e-07 bden=1 prog=1 dyn=0 zrf=0
VM_un_s6_rail1v8_vb_track_s2g2 BLS_s6_rail1v8_vb_track B_un_s6_rail1v8_vb_track_s2g2 0
X_un_s6_rail1v8_vb_track_s2g2 B_un_s6_rail1v8_vb_track_s2g2 WLON_s6_rail1v8_vb_track PL VB_s6_rail1v8_vb_track cell_candidate3_bd wcap=2.000000e-06 lcap=1.000000e-06 wacc=6.000000e-07 lacc=5.500000e-07 bden=1 prog=0 dyn=0
VM_pm_s6_rail1v8_vb_track_s2g2 BLS_s6_rail1v8_vb_track B_pm_s6_rail1v8_vb_track_s2g2 0
X_pm_s6_rail1v8_vb_track_s2g2 B_pm_s6_rail1v8_vb_track_s2g2 WLON_s6_rail1v8_vb_track PL VB_s6_rail1v8_vb_track cell_candidate3_bd wcap=2.000000e-06 lcap=1.000000e-06 wacc=6.000000e-07 lacc=5.500000e-07 bden=1 prog=1 dyn=0 zrf=0
VM_pw_s6_rail1v8_vb_track_s2g2 BLS_s6_rail1v8_vb_track B_pw_s6_rail1v8_vb_track_s2g2 0
X_pw_s6_rail1v8_vb_track_s2g2 B_pw_s6_rail1v8_vb_track_s2g2 WLON_s6_rail1v8_vb_track PL VB_s6_rail1v8_vb_track cell_candidate3_bd wcap=2.000000e-06 lcap=1.000000e-06 wacc=6.000000e-07 lacc=5.500000e-07 bden=1 prog=1 dyn=0 zrf={bd_zrf_wc}
EBL_s7_vb_track_p0v3 BLS_s7_vb_track_p0v3 0 BL 0 1.000000e+00
BVB_s7_vb_track_p0v3 VB_s7_vb_track_p0v3 0 V = 'v(bls_s7_vb_track_p0v3) + 3.000000e-01'
VWLON_s7_vb_track_p0v3 WLON_s7_vb_track_p0v3 0 DC 0.000000e+00
VM_off_s7_vb_track_p0v3_s1g1_lo BLS_s7_vb_track_p0v3 B_off_s7_vb_track_p0v3_s1g1_lo 0
X_off_s7_vb_track_p0v3_s1g1_lo B_off_s7_vb_track_p0v3_s1g1_lo WLLO PL VB_s7_vb_track_p0v3 cell_candidate3_bd wcap=1.000000e-06 lcap=1.000000e-06 wacc=3.000000e-07 lacc=5.500000e-07 bden=1 prog=0 dyn=0
VM_off_s7_vb_track_p0v3_s1g1_mid BLS_s7_vb_track_p0v3 B_off_s7_vb_track_p0v3_s1g1_mid 0
X_off_s7_vb_track_p0v3_s1g1_mid B_off_s7_vb_track_p0v3_s1g1_mid WLMID PL VB_s7_vb_track_p0v3 cell_candidate3_bd wcap=1.000000e-06 lcap=1.000000e-06 wacc=3.000000e-07 lacc=5.500000e-07 bden=1 prog=0 dyn=0
VM_off_s7_vb_track_p0v3_s1g1_hi BLS_s7_vb_track_p0v3 B_off_s7_vb_track_p0v3_s1g1_hi 0
X_off_s7_vb_track_p0v3_s1g1_hi B_off_s7_vb_track_p0v3_s1g1_hi WLHI PL VB_s7_vb_track_p0v3 cell_candidate3_bd wcap=1.000000e-06 lcap=1.000000e-06 wacc=3.000000e-07 lacc=5.500000e-07 bden=1 prog=0 dyn=0
VM_offp_s7_vb_track_p0v3_s1g1_lo BLS_s7_vb_track_p0v3 B_offp_s7_vb_track_p0v3_s1g1_lo 0
X_offp_s7_vb_track_p0v3_s1g1_lo B_offp_s7_vb_track_p0v3_s1g1_lo WLLO PL VB_s7_vb_track_p0v3 cell_candidate3_bd wcap=1.000000e-06 lcap=1.000000e-06 wacc=3.000000e-07 lacc=5.500000e-07 bden=1 prog=1 dyn=0 zrf=0
VM_offp_s7_vb_track_p0v3_s1g1_mid BLS_s7_vb_track_p0v3 B_offp_s7_vb_track_p0v3_s1g1_mid 0
X_offp_s7_vb_track_p0v3_s1g1_mid B_offp_s7_vb_track_p0v3_s1g1_mid WLMID PL VB_s7_vb_track_p0v3 cell_candidate3_bd wcap=1.000000e-06 lcap=1.000000e-06 wacc=3.000000e-07 lacc=5.500000e-07 bden=1 prog=1 dyn=0 zrf=0
VM_offp_s7_vb_track_p0v3_s1g1_hi BLS_s7_vb_track_p0v3 B_offp_s7_vb_track_p0v3_s1g1_hi 0
X_offp_s7_vb_track_p0v3_s1g1_hi B_offp_s7_vb_track_p0v3_s1g1_hi WLHI PL VB_s7_vb_track_p0v3 cell_candidate3_bd wcap=1.000000e-06 lcap=1.000000e-06 wacc=3.000000e-07 lacc=5.500000e-07 bden=1 prog=1 dyn=0 zrf=0
VM_un_s7_vb_track_p0v3_s1g1 BLS_s7_vb_track_p0v3 B_un_s7_vb_track_p0v3_s1g1 0
X_un_s7_vb_track_p0v3_s1g1 B_un_s7_vb_track_p0v3_s1g1 WLON_s7_vb_track_p0v3 PL VB_s7_vb_track_p0v3 cell_candidate3_bd wcap=1.000000e-06 lcap=1.000000e-06 wacc=3.000000e-07 lacc=5.500000e-07 bden=1 prog=0 dyn=0
VM_pm_s7_vb_track_p0v3_s1g1 BLS_s7_vb_track_p0v3 B_pm_s7_vb_track_p0v3_s1g1 0
X_pm_s7_vb_track_p0v3_s1g1 B_pm_s7_vb_track_p0v3_s1g1 WLON_s7_vb_track_p0v3 PL VB_s7_vb_track_p0v3 cell_candidate3_bd wcap=1.000000e-06 lcap=1.000000e-06 wacc=3.000000e-07 lacc=5.500000e-07 bden=1 prog=1 dyn=0 zrf=0
VM_pw_s7_vb_track_p0v3_s1g1 BLS_s7_vb_track_p0v3 B_pw_s7_vb_track_p0v3_s1g1 0
X_pw_s7_vb_track_p0v3_s1g1 B_pw_s7_vb_track_p0v3_s1g1 WLON_s7_vb_track_p0v3 PL VB_s7_vb_track_p0v3 cell_candidate3_bd wcap=1.000000e-06 lcap=1.000000e-06 wacc=3.000000e-07 lacc=5.500000e-07 bden=1 prog=1 dyn=0 zrf={bd_zrf_wc}
VM_off_s7_vb_track_p0v3_s1g2_lo BLS_s7_vb_track_p0v3 B_off_s7_vb_track_p0v3_s1g2_lo 0
X_off_s7_vb_track_p0v3_s1g2_lo B_off_s7_vb_track_p0v3_s1g2_lo WLLO PL VB_s7_vb_track_p0v3 cell_candidate3_bd wcap=2.000000e-06 lcap=1.000000e-06 wacc=3.000000e-07 lacc=5.500000e-07 bden=1 prog=0 dyn=0
VM_off_s7_vb_track_p0v3_s1g2_mid BLS_s7_vb_track_p0v3 B_off_s7_vb_track_p0v3_s1g2_mid 0
X_off_s7_vb_track_p0v3_s1g2_mid B_off_s7_vb_track_p0v3_s1g2_mid WLMID PL VB_s7_vb_track_p0v3 cell_candidate3_bd wcap=2.000000e-06 lcap=1.000000e-06 wacc=3.000000e-07 lacc=5.500000e-07 bden=1 prog=0 dyn=0
VM_off_s7_vb_track_p0v3_s1g2_hi BLS_s7_vb_track_p0v3 B_off_s7_vb_track_p0v3_s1g2_hi 0
X_off_s7_vb_track_p0v3_s1g2_hi B_off_s7_vb_track_p0v3_s1g2_hi WLHI PL VB_s7_vb_track_p0v3 cell_candidate3_bd wcap=2.000000e-06 lcap=1.000000e-06 wacc=3.000000e-07 lacc=5.500000e-07 bden=1 prog=0 dyn=0
VM_offp_s7_vb_track_p0v3_s1g2_lo BLS_s7_vb_track_p0v3 B_offp_s7_vb_track_p0v3_s1g2_lo 0
X_offp_s7_vb_track_p0v3_s1g2_lo B_offp_s7_vb_track_p0v3_s1g2_lo WLLO PL VB_s7_vb_track_p0v3 cell_candidate3_bd wcap=2.000000e-06 lcap=1.000000e-06 wacc=3.000000e-07 lacc=5.500000e-07 bden=1 prog=1 dyn=0 zrf=0
VM_offp_s7_vb_track_p0v3_s1g2_mid BLS_s7_vb_track_p0v3 B_offp_s7_vb_track_p0v3_s1g2_mid 0
X_offp_s7_vb_track_p0v3_s1g2_mid B_offp_s7_vb_track_p0v3_s1g2_mid WLMID PL VB_s7_vb_track_p0v3 cell_candidate3_bd wcap=2.000000e-06 lcap=1.000000e-06 wacc=3.000000e-07 lacc=5.500000e-07 bden=1 prog=1 dyn=0 zrf=0
VM_offp_s7_vb_track_p0v3_s1g2_hi BLS_s7_vb_track_p0v3 B_offp_s7_vb_track_p0v3_s1g2_hi 0
X_offp_s7_vb_track_p0v3_s1g2_hi B_offp_s7_vb_track_p0v3_s1g2_hi WLHI PL VB_s7_vb_track_p0v3 cell_candidate3_bd wcap=2.000000e-06 lcap=1.000000e-06 wacc=3.000000e-07 lacc=5.500000e-07 bden=1 prog=1 dyn=0 zrf=0
VM_un_s7_vb_track_p0v3_s1g2 BLS_s7_vb_track_p0v3 B_un_s7_vb_track_p0v3_s1g2 0
X_un_s7_vb_track_p0v3_s1g2 B_un_s7_vb_track_p0v3_s1g2 WLON_s7_vb_track_p0v3 PL VB_s7_vb_track_p0v3 cell_candidate3_bd wcap=2.000000e-06 lcap=1.000000e-06 wacc=3.000000e-07 lacc=5.500000e-07 bden=1 prog=0 dyn=0
VM_pm_s7_vb_track_p0v3_s1g2 BLS_s7_vb_track_p0v3 B_pm_s7_vb_track_p0v3_s1g2 0
X_pm_s7_vb_track_p0v3_s1g2 B_pm_s7_vb_track_p0v3_s1g2 WLON_s7_vb_track_p0v3 PL VB_s7_vb_track_p0v3 cell_candidate3_bd wcap=2.000000e-06 lcap=1.000000e-06 wacc=3.000000e-07 lacc=5.500000e-07 bden=1 prog=1 dyn=0 zrf=0
VM_pw_s7_vb_track_p0v3_s1g2 BLS_s7_vb_track_p0v3 B_pw_s7_vb_track_p0v3_s1g2 0
X_pw_s7_vb_track_p0v3_s1g2 B_pw_s7_vb_track_p0v3_s1g2 WLON_s7_vb_track_p0v3 PL VB_s7_vb_track_p0v3 cell_candidate3_bd wcap=2.000000e-06 lcap=1.000000e-06 wacc=3.000000e-07 lacc=5.500000e-07 bden=1 prog=1 dyn=0 zrf={bd_zrf_wc}
VM_off_s7_vb_track_p0v3_s2g1_lo BLS_s7_vb_track_p0v3 B_off_s7_vb_track_p0v3_s2g1_lo 0
X_off_s7_vb_track_p0v3_s2g1_lo B_off_s7_vb_track_p0v3_s2g1_lo WLLO PL VB_s7_vb_track_p0v3 cell_candidate3_bd wcap=1.000000e-06 lcap=1.000000e-06 wacc=6.000000e-07 lacc=5.500000e-07 bden=1 prog=0 dyn=0
VM_off_s7_vb_track_p0v3_s2g1_mid BLS_s7_vb_track_p0v3 B_off_s7_vb_track_p0v3_s2g1_mid 0
X_off_s7_vb_track_p0v3_s2g1_mid B_off_s7_vb_track_p0v3_s2g1_mid WLMID PL VB_s7_vb_track_p0v3 cell_candidate3_bd wcap=1.000000e-06 lcap=1.000000e-06 wacc=6.000000e-07 lacc=5.500000e-07 bden=1 prog=0 dyn=0
VM_off_s7_vb_track_p0v3_s2g1_hi BLS_s7_vb_track_p0v3 B_off_s7_vb_track_p0v3_s2g1_hi 0
X_off_s7_vb_track_p0v3_s2g1_hi B_off_s7_vb_track_p0v3_s2g1_hi WLHI PL VB_s7_vb_track_p0v3 cell_candidate3_bd wcap=1.000000e-06 lcap=1.000000e-06 wacc=6.000000e-07 lacc=5.500000e-07 bden=1 prog=0 dyn=0
VM_offp_s7_vb_track_p0v3_s2g1_lo BLS_s7_vb_track_p0v3 B_offp_s7_vb_track_p0v3_s2g1_lo 0
X_offp_s7_vb_track_p0v3_s2g1_lo B_offp_s7_vb_track_p0v3_s2g1_lo WLLO PL VB_s7_vb_track_p0v3 cell_candidate3_bd wcap=1.000000e-06 lcap=1.000000e-06 wacc=6.000000e-07 lacc=5.500000e-07 bden=1 prog=1 dyn=0 zrf=0
VM_offp_s7_vb_track_p0v3_s2g1_mid BLS_s7_vb_track_p0v3 B_offp_s7_vb_track_p0v3_s2g1_mid 0
X_offp_s7_vb_track_p0v3_s2g1_mid B_offp_s7_vb_track_p0v3_s2g1_mid WLMID PL VB_s7_vb_track_p0v3 cell_candidate3_bd wcap=1.000000e-06 lcap=1.000000e-06 wacc=6.000000e-07 lacc=5.500000e-07 bden=1 prog=1 dyn=0 zrf=0
VM_offp_s7_vb_track_p0v3_s2g1_hi BLS_s7_vb_track_p0v3 B_offp_s7_vb_track_p0v3_s2g1_hi 0
X_offp_s7_vb_track_p0v3_s2g1_hi B_offp_s7_vb_track_p0v3_s2g1_hi WLHI PL VB_s7_vb_track_p0v3 cell_candidate3_bd wcap=1.000000e-06 lcap=1.000000e-06 wacc=6.000000e-07 lacc=5.500000e-07 bden=1 prog=1 dyn=0 zrf=0
VM_un_s7_vb_track_p0v3_s2g1 BLS_s7_vb_track_p0v3 B_un_s7_vb_track_p0v3_s2g1 0
X_un_s7_vb_track_p0v3_s2g1 B_un_s7_vb_track_p0v3_s2g1 WLON_s7_vb_track_p0v3 PL VB_s7_vb_track_p0v3 cell_candidate3_bd wcap=1.000000e-06 lcap=1.000000e-06 wacc=6.000000e-07 lacc=5.500000e-07 bden=1 prog=0 dyn=0
VM_pm_s7_vb_track_p0v3_s2g1 BLS_s7_vb_track_p0v3 B_pm_s7_vb_track_p0v3_s2g1 0
X_pm_s7_vb_track_p0v3_s2g1 B_pm_s7_vb_track_p0v3_s2g1 WLON_s7_vb_track_p0v3 PL VB_s7_vb_track_p0v3 cell_candidate3_bd wcap=1.000000e-06 lcap=1.000000e-06 wacc=6.000000e-07 lacc=5.500000e-07 bden=1 prog=1 dyn=0 zrf=0
VM_pw_s7_vb_track_p0v3_s2g1 BLS_s7_vb_track_p0v3 B_pw_s7_vb_track_p0v3_s2g1 0
X_pw_s7_vb_track_p0v3_s2g1 B_pw_s7_vb_track_p0v3_s2g1 WLON_s7_vb_track_p0v3 PL VB_s7_vb_track_p0v3 cell_candidate3_bd wcap=1.000000e-06 lcap=1.000000e-06 wacc=6.000000e-07 lacc=5.500000e-07 bden=1 prog=1 dyn=0 zrf={bd_zrf_wc}
VM_off_s7_vb_track_p0v3_s2g2_lo BLS_s7_vb_track_p0v3 B_off_s7_vb_track_p0v3_s2g2_lo 0
X_off_s7_vb_track_p0v3_s2g2_lo B_off_s7_vb_track_p0v3_s2g2_lo WLLO PL VB_s7_vb_track_p0v3 cell_candidate3_bd wcap=2.000000e-06 lcap=1.000000e-06 wacc=6.000000e-07 lacc=5.500000e-07 bden=1 prog=0 dyn=0
VM_off_s7_vb_track_p0v3_s2g2_mid BLS_s7_vb_track_p0v3 B_off_s7_vb_track_p0v3_s2g2_mid 0
X_off_s7_vb_track_p0v3_s2g2_mid B_off_s7_vb_track_p0v3_s2g2_mid WLMID PL VB_s7_vb_track_p0v3 cell_candidate3_bd wcap=2.000000e-06 lcap=1.000000e-06 wacc=6.000000e-07 lacc=5.500000e-07 bden=1 prog=0 dyn=0
VM_off_s7_vb_track_p0v3_s2g2_hi BLS_s7_vb_track_p0v3 B_off_s7_vb_track_p0v3_s2g2_hi 0
X_off_s7_vb_track_p0v3_s2g2_hi B_off_s7_vb_track_p0v3_s2g2_hi WLHI PL VB_s7_vb_track_p0v3 cell_candidate3_bd wcap=2.000000e-06 lcap=1.000000e-06 wacc=6.000000e-07 lacc=5.500000e-07 bden=1 prog=0 dyn=0
VM_offp_s7_vb_track_p0v3_s2g2_lo BLS_s7_vb_track_p0v3 B_offp_s7_vb_track_p0v3_s2g2_lo 0
X_offp_s7_vb_track_p0v3_s2g2_lo B_offp_s7_vb_track_p0v3_s2g2_lo WLLO PL VB_s7_vb_track_p0v3 cell_candidate3_bd wcap=2.000000e-06 lcap=1.000000e-06 wacc=6.000000e-07 lacc=5.500000e-07 bden=1 prog=1 dyn=0 zrf=0
VM_offp_s7_vb_track_p0v3_s2g2_mid BLS_s7_vb_track_p0v3 B_offp_s7_vb_track_p0v3_s2g2_mid 0
X_offp_s7_vb_track_p0v3_s2g2_mid B_offp_s7_vb_track_p0v3_s2g2_mid WLMID PL VB_s7_vb_track_p0v3 cell_candidate3_bd wcap=2.000000e-06 lcap=1.000000e-06 wacc=6.000000e-07 lacc=5.500000e-07 bden=1 prog=1 dyn=0 zrf=0
VM_offp_s7_vb_track_p0v3_s2g2_hi BLS_s7_vb_track_p0v3 B_offp_s7_vb_track_p0v3_s2g2_hi 0
X_offp_s7_vb_track_p0v3_s2g2_hi B_offp_s7_vb_track_p0v3_s2g2_hi WLHI PL VB_s7_vb_track_p0v3 cell_candidate3_bd wcap=2.000000e-06 lcap=1.000000e-06 wacc=6.000000e-07 lacc=5.500000e-07 bden=1 prog=1 dyn=0 zrf=0
VM_un_s7_vb_track_p0v3_s2g2 BLS_s7_vb_track_p0v3 B_un_s7_vb_track_p0v3_s2g2 0
X_un_s7_vb_track_p0v3_s2g2 B_un_s7_vb_track_p0v3_s2g2 WLON_s7_vb_track_p0v3 PL VB_s7_vb_track_p0v3 cell_candidate3_bd wcap=2.000000e-06 lcap=1.000000e-06 wacc=6.000000e-07 lacc=5.500000e-07 bden=1 prog=0 dyn=0
VM_pm_s7_vb_track_p0v3_s2g2 BLS_s7_vb_track_p0v3 B_pm_s7_vb_track_p0v3_s2g2 0
X_pm_s7_vb_track_p0v3_s2g2 B_pm_s7_vb_track_p0v3_s2g2 WLON_s7_vb_track_p0v3 PL VB_s7_vb_track_p0v3 cell_candidate3_bd wcap=2.000000e-06 lcap=1.000000e-06 wacc=6.000000e-07 lacc=5.500000e-07 bden=1 prog=1 dyn=0 zrf=0
VM_pw_s7_vb_track_p0v3_s2g2 BLS_s7_vb_track_p0v3 B_pw_s7_vb_track_p0v3_s2g2 0
X_pw_s7_vb_track_p0v3_s2g2 B_pw_s7_vb_track_p0v3_s2g2 WLON_s7_vb_track_p0v3 PL VB_s7_vb_track_p0v3 cell_candidate3_bd wcap=2.000000e-06 lcap=1.000000e-06 wacc=6.000000e-07 lacc=5.500000e-07 bden=1 prog=1 dyn=0 zrf={bd_zrf_wc}
EBL_s8_vb_track_m0v3 BLS_s8_vb_track_m0v3 0 BL 0 1.000000e+00
BVB_s8_vb_track_m0v3 VB_s8_vb_track_m0v3 0 V = 'v(bls_s8_vb_track_m0v3) + -3.000000e-01'
VWLON_s8_vb_track_m0v3 WLON_s8_vb_track_m0v3 0 DC 0.000000e+00
VM_off_s8_vb_track_m0v3_s1g1_lo BLS_s8_vb_track_m0v3 B_off_s8_vb_track_m0v3_s1g1_lo 0
X_off_s8_vb_track_m0v3_s1g1_lo B_off_s8_vb_track_m0v3_s1g1_lo WLLO PL VB_s8_vb_track_m0v3 cell_candidate3_bd wcap=1.000000e-06 lcap=1.000000e-06 wacc=3.000000e-07 lacc=5.500000e-07 bden=1 prog=0 dyn=0
VM_off_s8_vb_track_m0v3_s1g1_mid BLS_s8_vb_track_m0v3 B_off_s8_vb_track_m0v3_s1g1_mid 0
X_off_s8_vb_track_m0v3_s1g1_mid B_off_s8_vb_track_m0v3_s1g1_mid WLMID PL VB_s8_vb_track_m0v3 cell_candidate3_bd wcap=1.000000e-06 lcap=1.000000e-06 wacc=3.000000e-07 lacc=5.500000e-07 bden=1 prog=0 dyn=0
VM_off_s8_vb_track_m0v3_s1g1_hi BLS_s8_vb_track_m0v3 B_off_s8_vb_track_m0v3_s1g1_hi 0
X_off_s8_vb_track_m0v3_s1g1_hi B_off_s8_vb_track_m0v3_s1g1_hi WLHI PL VB_s8_vb_track_m0v3 cell_candidate3_bd wcap=1.000000e-06 lcap=1.000000e-06 wacc=3.000000e-07 lacc=5.500000e-07 bden=1 prog=0 dyn=0
VM_offp_s8_vb_track_m0v3_s1g1_lo BLS_s8_vb_track_m0v3 B_offp_s8_vb_track_m0v3_s1g1_lo 0
X_offp_s8_vb_track_m0v3_s1g1_lo B_offp_s8_vb_track_m0v3_s1g1_lo WLLO PL VB_s8_vb_track_m0v3 cell_candidate3_bd wcap=1.000000e-06 lcap=1.000000e-06 wacc=3.000000e-07 lacc=5.500000e-07 bden=1 prog=1 dyn=0 zrf=0
VM_offp_s8_vb_track_m0v3_s1g1_mid BLS_s8_vb_track_m0v3 B_offp_s8_vb_track_m0v3_s1g1_mid 0
X_offp_s8_vb_track_m0v3_s1g1_mid B_offp_s8_vb_track_m0v3_s1g1_mid WLMID PL VB_s8_vb_track_m0v3 cell_candidate3_bd wcap=1.000000e-06 lcap=1.000000e-06 wacc=3.000000e-07 lacc=5.500000e-07 bden=1 prog=1 dyn=0 zrf=0
VM_offp_s8_vb_track_m0v3_s1g1_hi BLS_s8_vb_track_m0v3 B_offp_s8_vb_track_m0v3_s1g1_hi 0
X_offp_s8_vb_track_m0v3_s1g1_hi B_offp_s8_vb_track_m0v3_s1g1_hi WLHI PL VB_s8_vb_track_m0v3 cell_candidate3_bd wcap=1.000000e-06 lcap=1.000000e-06 wacc=3.000000e-07 lacc=5.500000e-07 bden=1 prog=1 dyn=0 zrf=0
VM_un_s8_vb_track_m0v3_s1g1 BLS_s8_vb_track_m0v3 B_un_s8_vb_track_m0v3_s1g1 0
X_un_s8_vb_track_m0v3_s1g1 B_un_s8_vb_track_m0v3_s1g1 WLON_s8_vb_track_m0v3 PL VB_s8_vb_track_m0v3 cell_candidate3_bd wcap=1.000000e-06 lcap=1.000000e-06 wacc=3.000000e-07 lacc=5.500000e-07 bden=1 prog=0 dyn=0
VM_pm_s8_vb_track_m0v3_s1g1 BLS_s8_vb_track_m0v3 B_pm_s8_vb_track_m0v3_s1g1 0
X_pm_s8_vb_track_m0v3_s1g1 B_pm_s8_vb_track_m0v3_s1g1 WLON_s8_vb_track_m0v3 PL VB_s8_vb_track_m0v3 cell_candidate3_bd wcap=1.000000e-06 lcap=1.000000e-06 wacc=3.000000e-07 lacc=5.500000e-07 bden=1 prog=1 dyn=0 zrf=0
VM_pw_s8_vb_track_m0v3_s1g1 BLS_s8_vb_track_m0v3 B_pw_s8_vb_track_m0v3_s1g1 0
X_pw_s8_vb_track_m0v3_s1g1 B_pw_s8_vb_track_m0v3_s1g1 WLON_s8_vb_track_m0v3 PL VB_s8_vb_track_m0v3 cell_candidate3_bd wcap=1.000000e-06 lcap=1.000000e-06 wacc=3.000000e-07 lacc=5.500000e-07 bden=1 prog=1 dyn=0 zrf={bd_zrf_wc}
VM_off_s8_vb_track_m0v3_s1g2_lo BLS_s8_vb_track_m0v3 B_off_s8_vb_track_m0v3_s1g2_lo 0
X_off_s8_vb_track_m0v3_s1g2_lo B_off_s8_vb_track_m0v3_s1g2_lo WLLO PL VB_s8_vb_track_m0v3 cell_candidate3_bd wcap=2.000000e-06 lcap=1.000000e-06 wacc=3.000000e-07 lacc=5.500000e-07 bden=1 prog=0 dyn=0
VM_off_s8_vb_track_m0v3_s1g2_mid BLS_s8_vb_track_m0v3 B_off_s8_vb_track_m0v3_s1g2_mid 0
X_off_s8_vb_track_m0v3_s1g2_mid B_off_s8_vb_track_m0v3_s1g2_mid WLMID PL VB_s8_vb_track_m0v3 cell_candidate3_bd wcap=2.000000e-06 lcap=1.000000e-06 wacc=3.000000e-07 lacc=5.500000e-07 bden=1 prog=0 dyn=0
VM_off_s8_vb_track_m0v3_s1g2_hi BLS_s8_vb_track_m0v3 B_off_s8_vb_track_m0v3_s1g2_hi 0
X_off_s8_vb_track_m0v3_s1g2_hi B_off_s8_vb_track_m0v3_s1g2_hi WLHI PL VB_s8_vb_track_m0v3 cell_candidate3_bd wcap=2.000000e-06 lcap=1.000000e-06 wacc=3.000000e-07 lacc=5.500000e-07 bden=1 prog=0 dyn=0
VM_offp_s8_vb_track_m0v3_s1g2_lo BLS_s8_vb_track_m0v3 B_offp_s8_vb_track_m0v3_s1g2_lo 0
X_offp_s8_vb_track_m0v3_s1g2_lo B_offp_s8_vb_track_m0v3_s1g2_lo WLLO PL VB_s8_vb_track_m0v3 cell_candidate3_bd wcap=2.000000e-06 lcap=1.000000e-06 wacc=3.000000e-07 lacc=5.500000e-07 bden=1 prog=1 dyn=0 zrf=0
VM_offp_s8_vb_track_m0v3_s1g2_mid BLS_s8_vb_track_m0v3 B_offp_s8_vb_track_m0v3_s1g2_mid 0
X_offp_s8_vb_track_m0v3_s1g2_mid B_offp_s8_vb_track_m0v3_s1g2_mid WLMID PL VB_s8_vb_track_m0v3 cell_candidate3_bd wcap=2.000000e-06 lcap=1.000000e-06 wacc=3.000000e-07 lacc=5.500000e-07 bden=1 prog=1 dyn=0 zrf=0
VM_offp_s8_vb_track_m0v3_s1g2_hi BLS_s8_vb_track_m0v3 B_offp_s8_vb_track_m0v3_s1g2_hi 0
X_offp_s8_vb_track_m0v3_s1g2_hi B_offp_s8_vb_track_m0v3_s1g2_hi WLHI PL VB_s8_vb_track_m0v3 cell_candidate3_bd wcap=2.000000e-06 lcap=1.000000e-06 wacc=3.000000e-07 lacc=5.500000e-07 bden=1 prog=1 dyn=0 zrf=0
VM_un_s8_vb_track_m0v3_s1g2 BLS_s8_vb_track_m0v3 B_un_s8_vb_track_m0v3_s1g2 0
X_un_s8_vb_track_m0v3_s1g2 B_un_s8_vb_track_m0v3_s1g2 WLON_s8_vb_track_m0v3 PL VB_s8_vb_track_m0v3 cell_candidate3_bd wcap=2.000000e-06 lcap=1.000000e-06 wacc=3.000000e-07 lacc=5.500000e-07 bden=1 prog=0 dyn=0
VM_pm_s8_vb_track_m0v3_s1g2 BLS_s8_vb_track_m0v3 B_pm_s8_vb_track_m0v3_s1g2 0
X_pm_s8_vb_track_m0v3_s1g2 B_pm_s8_vb_track_m0v3_s1g2 WLON_s8_vb_track_m0v3 PL VB_s8_vb_track_m0v3 cell_candidate3_bd wcap=2.000000e-06 lcap=1.000000e-06 wacc=3.000000e-07 lacc=5.500000e-07 bden=1 prog=1 dyn=0 zrf=0
VM_pw_s8_vb_track_m0v3_s1g2 BLS_s8_vb_track_m0v3 B_pw_s8_vb_track_m0v3_s1g2 0
X_pw_s8_vb_track_m0v3_s1g2 B_pw_s8_vb_track_m0v3_s1g2 WLON_s8_vb_track_m0v3 PL VB_s8_vb_track_m0v3 cell_candidate3_bd wcap=2.000000e-06 lcap=1.000000e-06 wacc=3.000000e-07 lacc=5.500000e-07 bden=1 prog=1 dyn=0 zrf={bd_zrf_wc}
VM_off_s8_vb_track_m0v3_s2g1_lo BLS_s8_vb_track_m0v3 B_off_s8_vb_track_m0v3_s2g1_lo 0
X_off_s8_vb_track_m0v3_s2g1_lo B_off_s8_vb_track_m0v3_s2g1_lo WLLO PL VB_s8_vb_track_m0v3 cell_candidate3_bd wcap=1.000000e-06 lcap=1.000000e-06 wacc=6.000000e-07 lacc=5.500000e-07 bden=1 prog=0 dyn=0
VM_off_s8_vb_track_m0v3_s2g1_mid BLS_s8_vb_track_m0v3 B_off_s8_vb_track_m0v3_s2g1_mid 0
X_off_s8_vb_track_m0v3_s2g1_mid B_off_s8_vb_track_m0v3_s2g1_mid WLMID PL VB_s8_vb_track_m0v3 cell_candidate3_bd wcap=1.000000e-06 lcap=1.000000e-06 wacc=6.000000e-07 lacc=5.500000e-07 bden=1 prog=0 dyn=0
VM_off_s8_vb_track_m0v3_s2g1_hi BLS_s8_vb_track_m0v3 B_off_s8_vb_track_m0v3_s2g1_hi 0
X_off_s8_vb_track_m0v3_s2g1_hi B_off_s8_vb_track_m0v3_s2g1_hi WLHI PL VB_s8_vb_track_m0v3 cell_candidate3_bd wcap=1.000000e-06 lcap=1.000000e-06 wacc=6.000000e-07 lacc=5.500000e-07 bden=1 prog=0 dyn=0
VM_offp_s8_vb_track_m0v3_s2g1_lo BLS_s8_vb_track_m0v3 B_offp_s8_vb_track_m0v3_s2g1_lo 0
X_offp_s8_vb_track_m0v3_s2g1_lo B_offp_s8_vb_track_m0v3_s2g1_lo WLLO PL VB_s8_vb_track_m0v3 cell_candidate3_bd wcap=1.000000e-06 lcap=1.000000e-06 wacc=6.000000e-07 lacc=5.500000e-07 bden=1 prog=1 dyn=0 zrf=0
VM_offp_s8_vb_track_m0v3_s2g1_mid BLS_s8_vb_track_m0v3 B_offp_s8_vb_track_m0v3_s2g1_mid 0
X_offp_s8_vb_track_m0v3_s2g1_mid B_offp_s8_vb_track_m0v3_s2g1_mid WLMID PL VB_s8_vb_track_m0v3 cell_candidate3_bd wcap=1.000000e-06 lcap=1.000000e-06 wacc=6.000000e-07 lacc=5.500000e-07 bden=1 prog=1 dyn=0 zrf=0
VM_offp_s8_vb_track_m0v3_s2g1_hi BLS_s8_vb_track_m0v3 B_offp_s8_vb_track_m0v3_s2g1_hi 0
X_offp_s8_vb_track_m0v3_s2g1_hi B_offp_s8_vb_track_m0v3_s2g1_hi WLHI PL VB_s8_vb_track_m0v3 cell_candidate3_bd wcap=1.000000e-06 lcap=1.000000e-06 wacc=6.000000e-07 lacc=5.500000e-07 bden=1 prog=1 dyn=0 zrf=0
VM_un_s8_vb_track_m0v3_s2g1 BLS_s8_vb_track_m0v3 B_un_s8_vb_track_m0v3_s2g1 0
X_un_s8_vb_track_m0v3_s2g1 B_un_s8_vb_track_m0v3_s2g1 WLON_s8_vb_track_m0v3 PL VB_s8_vb_track_m0v3 cell_candidate3_bd wcap=1.000000e-06 lcap=1.000000e-06 wacc=6.000000e-07 lacc=5.500000e-07 bden=1 prog=0 dyn=0
VM_pm_s8_vb_track_m0v3_s2g1 BLS_s8_vb_track_m0v3 B_pm_s8_vb_track_m0v3_s2g1 0
X_pm_s8_vb_track_m0v3_s2g1 B_pm_s8_vb_track_m0v3_s2g1 WLON_s8_vb_track_m0v3 PL VB_s8_vb_track_m0v3 cell_candidate3_bd wcap=1.000000e-06 lcap=1.000000e-06 wacc=6.000000e-07 lacc=5.500000e-07 bden=1 prog=1 dyn=0 zrf=0
VM_pw_s8_vb_track_m0v3_s2g1 BLS_s8_vb_track_m0v3 B_pw_s8_vb_track_m0v3_s2g1 0
X_pw_s8_vb_track_m0v3_s2g1 B_pw_s8_vb_track_m0v3_s2g1 WLON_s8_vb_track_m0v3 PL VB_s8_vb_track_m0v3 cell_candidate3_bd wcap=1.000000e-06 lcap=1.000000e-06 wacc=6.000000e-07 lacc=5.500000e-07 bden=1 prog=1 dyn=0 zrf={bd_zrf_wc}
VM_off_s8_vb_track_m0v3_s2g2_lo BLS_s8_vb_track_m0v3 B_off_s8_vb_track_m0v3_s2g2_lo 0
X_off_s8_vb_track_m0v3_s2g2_lo B_off_s8_vb_track_m0v3_s2g2_lo WLLO PL VB_s8_vb_track_m0v3 cell_candidate3_bd wcap=2.000000e-06 lcap=1.000000e-06 wacc=6.000000e-07 lacc=5.500000e-07 bden=1 prog=0 dyn=0
VM_off_s8_vb_track_m0v3_s2g2_mid BLS_s8_vb_track_m0v3 B_off_s8_vb_track_m0v3_s2g2_mid 0
X_off_s8_vb_track_m0v3_s2g2_mid B_off_s8_vb_track_m0v3_s2g2_mid WLMID PL VB_s8_vb_track_m0v3 cell_candidate3_bd wcap=2.000000e-06 lcap=1.000000e-06 wacc=6.000000e-07 lacc=5.500000e-07 bden=1 prog=0 dyn=0
VM_off_s8_vb_track_m0v3_s2g2_hi BLS_s8_vb_track_m0v3 B_off_s8_vb_track_m0v3_s2g2_hi 0
X_off_s8_vb_track_m0v3_s2g2_hi B_off_s8_vb_track_m0v3_s2g2_hi WLHI PL VB_s8_vb_track_m0v3 cell_candidate3_bd wcap=2.000000e-06 lcap=1.000000e-06 wacc=6.000000e-07 lacc=5.500000e-07 bden=1 prog=0 dyn=0
VM_offp_s8_vb_track_m0v3_s2g2_lo BLS_s8_vb_track_m0v3 B_offp_s8_vb_track_m0v3_s2g2_lo 0
X_offp_s8_vb_track_m0v3_s2g2_lo B_offp_s8_vb_track_m0v3_s2g2_lo WLLO PL VB_s8_vb_track_m0v3 cell_candidate3_bd wcap=2.000000e-06 lcap=1.000000e-06 wacc=6.000000e-07 lacc=5.500000e-07 bden=1 prog=1 dyn=0 zrf=0
VM_offp_s8_vb_track_m0v3_s2g2_mid BLS_s8_vb_track_m0v3 B_offp_s8_vb_track_m0v3_s2g2_mid 0
X_offp_s8_vb_track_m0v3_s2g2_mid B_offp_s8_vb_track_m0v3_s2g2_mid WLMID PL VB_s8_vb_track_m0v3 cell_candidate3_bd wcap=2.000000e-06 lcap=1.000000e-06 wacc=6.000000e-07 lacc=5.500000e-07 bden=1 prog=1 dyn=0 zrf=0
VM_offp_s8_vb_track_m0v3_s2g2_hi BLS_s8_vb_track_m0v3 B_offp_s8_vb_track_m0v3_s2g2_hi 0
X_offp_s8_vb_track_m0v3_s2g2_hi B_offp_s8_vb_track_m0v3_s2g2_hi WLHI PL VB_s8_vb_track_m0v3 cell_candidate3_bd wcap=2.000000e-06 lcap=1.000000e-06 wacc=6.000000e-07 lacc=5.500000e-07 bden=1 prog=1 dyn=0 zrf=0
VM_un_s8_vb_track_m0v3_s2g2 BLS_s8_vb_track_m0v3 B_un_s8_vb_track_m0v3_s2g2 0
X_un_s8_vb_track_m0v3_s2g2 B_un_s8_vb_track_m0v3_s2g2 WLON_s8_vb_track_m0v3 PL VB_s8_vb_track_m0v3 cell_candidate3_bd wcap=2.000000e-06 lcap=1.000000e-06 wacc=6.000000e-07 lacc=5.500000e-07 bden=1 prog=0 dyn=0
VM_pm_s8_vb_track_m0v3_s2g2 BLS_s8_vb_track_m0v3 B_pm_s8_vb_track_m0v3_s2g2 0
X_pm_s8_vb_track_m0v3_s2g2 B_pm_s8_vb_track_m0v3_s2g2 WLON_s8_vb_track_m0v3 PL VB_s8_vb_track_m0v3 cell_candidate3_bd wcap=2.000000e-06 lcap=1.000000e-06 wacc=6.000000e-07 lacc=5.500000e-07 bden=1 prog=1 dyn=0 zrf=0
VM_pw_s8_vb_track_m0v3_s2g2 BLS_s8_vb_track_m0v3 B_pw_s8_vb_track_m0v3_s2g2 0
X_pw_s8_vb_track_m0v3_s2g2 B_pw_s8_vb_track_m0v3_s2g2 WLON_s8_vb_track_m0v3 PL VB_s8_vb_track_m0v3 cell_candidate3_bd wcap=2.000000e-06 lcap=1.000000e-06 wacc=6.000000e-07 lacc=5.500000e-07 bden=1 prog=1 dyn=0 zrf={bd_zrf_wc}
