* gf180-antifuse sim/array-slice-bench: slice_ii_iii, process corner typical (GENERATED by make_bench.py - do not edit)
* Circuit body for `klt sim`. The MOS and moscap sections come from the request's
* corner bundle; design.ngspice (global switches) and the 10 V LDMOS library's
* matching section (typical) are resolved from $PDK_ROOT on whichever host runs the corner.
.include $PDK_ROOT/gf180mcuD/libs.tech/ngspice/design.ngspice
.lib "$PDK_ROOT/gf180mcuD/libs.tech/ngspice/smbb000149.ngspice" typical
* derived netlists of the design under test (design/netlists/, never copied)
.include ../../../design/netlists/cell_candidate1.spice
.include ../../../design/netlists/cell_candidate2.spice
.include ../../../design/netlists/cell_candidate3.spice
.include ../../../design/netlists/ls_hv06.spice
.include ../../../design/netlists/ls_hv10.spice
.include ../../../design/netlists/pg_n06.spice
.include ../../../design/netlists/pg_n10.spice
.include ../../../design/netlists/slice_ii_iii.spice

X_dut RSEL_0 RSEL_1 RSEL_2 RSEL_3 CSEL_20 CSEL_21 CSEL_22 CSEL_23 BLG_II PLG_II BLG_III PLG_III VDDH_II VDDH_III VDDL VSS slice_ii_iii

Vddl VDDL 0 DC 3.3
Vss VSS 0 DC 0
Vrsel0 RSEL_0 0 DC 0
Vrsel1 RSEL_1 0 DC 0
Vrsel2 RSEL_2 0 DC 0
Vrsel3 RSEL_3 0 DC 0
Vcsel20 CSEL_20 0 DC 0
Vcsel21 CSEL_21 0 DC 0
Vcsel22 CSEL_22 0 DC 0
Vcsel23 CSEL_23 0 DC 0

* dummy sweep source: the dc analysis needs a swept source with a >0-width interval so
* `.meas dc ... AT=0` has something to interpolate; it drives nothing in the design
Vdum NDUM 0 DC 0
Rdum NDUM 0 1k

* per-band rails, global bit-line bus stand-in level, return bus
Vddh_II VDDH_II 0 DC 5.5
Vbl_II BLG_II 0 DC 3.5
Vplg_II PLG_II 0 DC 0
Vddh_III VDDH_III 0 DC 5.0
Vbl_III BLG_III 0 DC 3.0
Vplg_III PLG_III 0 DC 0

* bench-only filament stand-in (1e+06 ohm) across every cell capacitor,
* with a 0 V sense source: i(vfil_<row>_<col>) is that cell's access-path current
Rfil_0_20 x_dut.xc_0_20.cn nf_0_20 1e+06
Vfil_0_20 nf_0_20 x_dut.pl_0_II 0
Rfil_0_21 x_dut.xc_0_21.cn nf_0_21 1e+06
Vfil_0_21 nf_0_21 x_dut.pl_0_II 0
Rfil_0_22 x_dut.xc_0_22.cn nf_0_22 1e+06
Vfil_0_22 nf_0_22 x_dut.pl_0_III 0
Rfil_0_23 x_dut.xc_0_23.cn nf_0_23 1e+06
Vfil_0_23 nf_0_23 x_dut.pl_0_III 0
Rfil_1_20 x_dut.xc_1_20.cn nf_1_20 1e+06
Vfil_1_20 nf_1_20 x_dut.pl_1_II 0
Rfil_1_21 x_dut.xc_1_21.cn nf_1_21 1e+06
Vfil_1_21 nf_1_21 x_dut.pl_1_II 0
Rfil_1_22 x_dut.xc_1_22.cn nf_1_22 1e+06
Vfil_1_22 nf_1_22 x_dut.pl_1_III 0
Rfil_1_23 x_dut.xc_1_23.cn nf_1_23 1e+06
Vfil_1_23 nf_1_23 x_dut.pl_1_III 0
Rfil_2_20 x_dut.xc_2_20.cn nf_2_20 1e+06
Vfil_2_20 nf_2_20 x_dut.pl_2_II 0
Rfil_2_21 x_dut.xc_2_21.cn nf_2_21 1e+06
Vfil_2_21 nf_2_21 x_dut.pl_2_II 0
Rfil_2_22 x_dut.xc_2_22.cn nf_2_22 1e+06
Vfil_2_22 nf_2_22 x_dut.pl_2_III 0
Rfil_2_23 x_dut.xc_2_23.cn nf_2_23 1e+06
Vfil_2_23 nf_2_23 x_dut.pl_2_III 0
Rfil_3_20 x_dut.xc_3_20.cn nf_3_20 1e+06
Vfil_3_20 nf_3_20 x_dut.pl_3_II 0
Rfil_3_21 x_dut.xc_3_21.cn nf_3_21 1e+06
Vfil_3_21 nf_3_21 x_dut.pl_3_II 0
Rfil_3_22 x_dut.xc_3_22.cn nf_3_22 1e+06
Vfil_3_22 nf_3_22 x_dut.pl_3_III 0
Rfil_3_23 x_dut.xc_3_23.cn nf_3_23 1e+06
Vfil_3_23 nf_3_23 x_dut.pl_3_III 0
