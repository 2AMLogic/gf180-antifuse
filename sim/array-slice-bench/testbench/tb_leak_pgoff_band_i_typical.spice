* gf180-antifuse sim/array-slice-bench: full-band leakage, band_i, variant pgoff, process corner typical (GENERATED by make_bench.py - do not edit)
* Circuit body for `klt sim`. See make_bench.py (Full-band leakage) and README.md.
.include $PDK_ROOT/gf180mcuD/libs.tech/ngspice/design.ngspice
.lib "$PDK_ROOT/gf180mcuD/libs.tech/ngspice/smbb000149.ngspice" typical
* derived netlists of the design under test (design/netlists/, never copied)
.include ../../../design/netlists/cell_candidate1.spice
.include ../../../design/netlists/cell_candidate2.spice
.include ../../../design/netlists/cell_candidate3.spice
.include ../../../design/netlists/ls_hv06.spice
.include ../../../design/netlists/ls_hv10.spice
.include ../../../design/netlists/pg_n06.spice
.include ../../../design/netlists/pg_n10.spice
.include ../../../design/netlists/band_i.spice

X_dut RSEL_0 RSEL_1 RSEL_2 RSEL_3 CSEL_0 CSEL_1 CSEL_2 CSEL_3 CSEL_4 CSEL_5 CSEL_6 CSEL_7 CSEL_8 CSEL_9 CSEL_10 BLG_I PLG_I VDDH_I VDDL VSS band_i

Vddl VDDL 0 DC 3.3
Vss VSS 0 DC 0
Vrsel0 RSEL_0 0 DC 0
Vrsel1 RSEL_1 0 DC 0
Vrsel2 RSEL_2 0 DC 0
Vrsel3 RSEL_3 0 DC 0
Vcsel0 CSEL_0 0 DC 0
Vcsel1 CSEL_1 0 DC 0
Vcsel2 CSEL_2 0 DC 0
Vcsel3 CSEL_3 0 DC 0
Vcsel4 CSEL_4 0 DC 0
Vcsel5 CSEL_5 0 DC 0
Vcsel6 CSEL_6 0 DC 0
Vcsel7 CSEL_7 0 DC 0
Vcsel8 CSEL_8 0 DC 0
Vcsel9 CSEL_9 0 DC 0
Vcsel10 CSEL_10 0 DC 0

Vdum NDUM 0 DC 0
Rdum NDUM 0 1k

* band rail, BLG = the assumed sense node held at the read level, PLG return
Vddh_I VDDH_I 0 DC 5.0
Vbl_I BLG_I 0 DC 0.5
Vplg_I PLG_I 0 DC 0

* every BL_c clamped at 0 V: the OFF column pass-gate sees the full BLG level across
* it and the cell access devices see V_DS = 0 (cell term is NOT in this variant).
* i(vcl_<c>) = current the pass-gate delivers into BL_c (positive = out of BLG).
Vcl_0 x_dut.bl_0 0 DC 0
Vcl_1 x_dut.bl_1 0 DC 0
Vcl_2 x_dut.bl_2 0 DC 0
Vcl_3 x_dut.bl_3 0 DC 0
Vcl_4 x_dut.bl_4 0 DC 0
Vcl_5 x_dut.bl_5 0 DC 0
Vcl_6 x_dut.bl_6 0 DC 0
Vcl_7 x_dut.bl_7 0 DC 0
Vcl_8 x_dut.bl_8 0 DC 0
Vcl_9 x_dut.bl_9 0 DC 0
Vcl_10 x_dut.bl_10 0 DC 0
