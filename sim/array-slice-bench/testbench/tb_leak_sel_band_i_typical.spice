* gf180-antifuse sim/array-slice-bench: full-band leakage, band_i, variant sel, process corner typical (GENERATED by make_bench.py - do not edit)
* Circuit body for `klt sim`. See make_bench.py (Full-band leakage) and README.md.
.include $PDK_ROOT/gf180mcuD/libs.tech/ngspice/design.ngspice
.lib "$PDK_ROOT/gf180mcuD/libs.tech/ngspice/smbb000149.ngspice" typical
* derived netlists of the design under test (design/netlists/, never copied)
.include ../../../design/netlists/cell_candidate1.spice
.include ../../../design/netlists/cell_candidate2.spice
.include ../../../design/netlists/cell_candidate3.spice
.include ../../../design/netlists/ls_hv06.spice
.include ../../../design/netlists/ls_hv10.spice
.include ../../../design/netlists/pg_n06.spice
.include ../../../design/netlists/pg_n10.spice
.include ../../../design/netlists/band_i.spice

X_dut RSEL_0 RSEL_1 RSEL_2 RSEL_3 CSEL_0 CSEL_1 CSEL_2 CSEL_3 CSEL_4 CSEL_5 CSEL_6 CSEL_7 CSEL_8 CSEL_9 CSEL_10 BLG_I PLG_I VDDH_I VDDL VSS band_i

Vddl VDDL 0 DC 3.3
Vss VSS 0 DC 0
Vrsel0 RSEL_0 0 DC 0
Vrsel1 RSEL_1 0 DC 0
Vrsel2 RSEL_2 0 DC 0
Vrsel3 RSEL_3 0 DC 0
Vcsel0 CSEL_0 0 DC 0
Vcsel1 CSEL_1 0 DC 0
Vcsel2 CSEL_2 0 DC 0
Vcsel3 CSEL_3 0 DC 0
Vcsel4 CSEL_4 0 DC 0
Vcsel5 CSEL_5 0 DC 0
Vcsel6 CSEL_6 0 DC 0
Vcsel7 CSEL_7 0 DC 0
Vcsel8 CSEL_8 0 DC 0
Vcsel9 CSEL_9 0 DC 0
Vcsel10 CSEL_10 0 DC 0

Vdum NDUM 0 DC 0
Rdum NDUM 0 1k

* band rail, BLG = the assumed sense node held at the read level, PLG return
Vddh_I VDDH_I 0 DC 5.0
Vbl_I BLG_I 0 DC 0.5
Vplg_I PLG_I 0 DC 0

* bench-only filament stand-in (1e+06 ohm) across every cell capacitor (see the
* slice bench above); the selected cell's path is the read path being checked
Rfil_0_0 x_dut.xc_0_0.cn nf_0_0 1e+06
Vfil_0_0 nf_0_0 x_dut.pl_0_I 0
Rfil_0_1 x_dut.xc_0_1.cn nf_0_1 1e+06
Vfil_0_1 nf_0_1 x_dut.pl_0_I 0
Rfil_0_2 x_dut.xc_0_2.cn nf_0_2 1e+06
Vfil_0_2 nf_0_2 x_dut.pl_0_I 0
Rfil_0_3 x_dut.xc_0_3.cn nf_0_3 1e+06
Vfil_0_3 nf_0_3 x_dut.pl_0_I 0
Rfil_0_4 x_dut.xc_0_4.cn nf_0_4 1e+06
Vfil_0_4 nf_0_4 x_dut.pl_0_I 0
Rfil_0_5 x_dut.xc_0_5.cn nf_0_5 1e+06
Vfil_0_5 nf_0_5 x_dut.pl_0_I 0
Rfil_0_6 x_dut.xc_0_6.cn nf_0_6 1e+06
Vfil_0_6 nf_0_6 x_dut.pl_0_I 0
Rfil_0_7 x_dut.xc_0_7.cn nf_0_7 1e+06
Vfil_0_7 nf_0_7 x_dut.pl_0_I 0
Rfil_0_8 x_dut.xc_0_8.cn nf_0_8 1e+06
Vfil_0_8 nf_0_8 x_dut.pl_0_I 0
Rfil_0_9 x_dut.xc_0_9.cn nf_0_9 1e+06
Vfil_0_9 nf_0_9 x_dut.pl_0_I 0
Rfil_0_10 x_dut.xc_0_10.cn nf_0_10 1e+06
Vfil_0_10 nf_0_10 x_dut.pl_0_I 0
Rfil_1_0 x_dut.xc_1_0.cn nf_1_0 1e+06
Vfil_1_0 nf_1_0 x_dut.pl_1_I 0
Rfil_1_1 x_dut.xc_1_1.cn nf_1_1 1e+06
Vfil_1_1 nf_1_1 x_dut.pl_1_I 0
Rfil_1_2 x_dut.xc_1_2.cn nf_1_2 1e+06
Vfil_1_2 nf_1_2 x_dut.pl_1_I 0
Rfil_1_3 x_dut.xc_1_3.cn nf_1_3 1e+06
Vfil_1_3 nf_1_3 x_dut.pl_1_I 0
Rfil_1_4 x_dut.xc_1_4.cn nf_1_4 1e+06
Vfil_1_4 nf_1_4 x_dut.pl_1_I 0
Rfil_1_5 x_dut.xc_1_5.cn nf_1_5 1e+06
Vfil_1_5 nf_1_5 x_dut.pl_1_I 0
Rfil_1_6 x_dut.xc_1_6.cn nf_1_6 1e+06
Vfil_1_6 nf_1_6 x_dut.pl_1_I 0
Rfil_1_7 x_dut.xc_1_7.cn nf_1_7 1e+06
Vfil_1_7 nf_1_7 x_dut.pl_1_I 0
Rfil_1_8 x_dut.xc_1_8.cn nf_1_8 1e+06
Vfil_1_8 nf_1_8 x_dut.pl_1_I 0
Rfil_1_9 x_dut.xc_1_9.cn nf_1_9 1e+06
Vfil_1_9 nf_1_9 x_dut.pl_1_I 0
Rfil_1_10 x_dut.xc_1_10.cn nf_1_10 1e+06
Vfil_1_10 nf_1_10 x_dut.pl_1_I 0
Rfil_2_0 x_dut.xc_2_0.cn nf_2_0 1e+06
Vfil_2_0 nf_2_0 x_dut.pl_2_I 0
Rfil_2_1 x_dut.xc_2_1.cn nf_2_1 1e+06
Vfil_2_1 nf_2_1 x_dut.pl_2_I 0
Rfil_2_2 x_dut.xc_2_2.cn nf_2_2 1e+06
Vfil_2_2 nf_2_2 x_dut.pl_2_I 0
Rfil_2_3 x_dut.xc_2_3.cn nf_2_3 1e+06
Vfil_2_3 nf_2_3 x_dut.pl_2_I 0
Rfil_2_4 x_dut.xc_2_4.cn nf_2_4 1e+06
Vfil_2_4 nf_2_4 x_dut.pl_2_I 0
Rfil_2_5 x_dut.xc_2_5.cn nf_2_5 1e+06
Vfil_2_5 nf_2_5 x_dut.pl_2_I 0
Rfil_2_6 x_dut.xc_2_6.cn nf_2_6 1e+06
Vfil_2_6 nf_2_6 x_dut.pl_2_I 0
Rfil_2_7 x_dut.xc_2_7.cn nf_2_7 1e+06
Vfil_2_7 nf_2_7 x_dut.pl_2_I 0
Rfil_2_8 x_dut.xc_2_8.cn nf_2_8 1e+06
Vfil_2_8 nf_2_8 x_dut.pl_2_I 0
Rfil_2_9 x_dut.xc_2_9.cn nf_2_9 1e+06
Vfil_2_9 nf_2_9 x_dut.pl_2_I 0
Rfil_2_10 x_dut.xc_2_10.cn nf_2_10 1e+06
Vfil_2_10 nf_2_10 x_dut.pl_2_I 0
Rfil_3_0 x_dut.xc_3_0.cn nf_3_0 1e+06
Vfil_3_0 nf_3_0 x_dut.pl_3_I 0
Rfil_3_1 x_dut.xc_3_1.cn nf_3_1 1e+06
Vfil_3_1 nf_3_1 x_dut.pl_3_I 0
Rfil_3_2 x_dut.xc_3_2.cn nf_3_2 1e+06
Vfil_3_2 nf_3_2 x_dut.pl_3_I 0
Rfil_3_3 x_dut.xc_3_3.cn nf_3_3 1e+06
Vfil_3_3 nf_3_3 x_dut.pl_3_I 0
Rfil_3_4 x_dut.xc_3_4.cn nf_3_4 1e+06
Vfil_3_4 nf_3_4 x_dut.pl_3_I 0
Rfil_3_5 x_dut.xc_3_5.cn nf_3_5 1e+06
Vfil_3_5 nf_3_5 x_dut.pl_3_I 0
Rfil_3_6 x_dut.xc_3_6.cn nf_3_6 1e+06
Vfil_3_6 nf_3_6 x_dut.pl_3_I 0
Rfil_3_7 x_dut.xc_3_7.cn nf_3_7 1e+06
Vfil_3_7 nf_3_7 x_dut.pl_3_I 0
Rfil_3_8 x_dut.xc_3_8.cn nf_3_8 1e+06
Vfil_3_8 nf_3_8 x_dut.pl_3_I 0
Rfil_3_9 x_dut.xc_3_9.cn nf_3_9 1e+06
Vfil_3_9 nf_3_9 x_dut.pl_3_I 0
Rfil_3_10 x_dut.xc_3_10.cn nf_3_10 1e+06
Vfil_3_10 nf_3_10 x_dut.pl_3_I 0
