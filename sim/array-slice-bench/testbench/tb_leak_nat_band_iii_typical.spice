* gf180-antifuse sim/array-slice-bench: full-band leakage, band_iii, variant nat, process corner typical (GENERATED by make_bench.py - do not edit)
* Circuit body for `klt sim`. See make_bench.py (Full-band leakage) and README.md.
.include $PDK_ROOT/gf180mcuD/libs.tech/ngspice/design.ngspice
.lib "$PDK_ROOT/gf180mcuD/libs.tech/ngspice/smbb000149.ngspice" typical
* derived netlists of the design under test (design/netlists/, never copied)
.include ../../../design/netlists/cell_candidate1.spice
.include ../../../design/netlists/cell_candidate2.spice
.include ../../../design/netlists/cell_candidate3.spice
.include ../../../design/netlists/ls_hv06.spice
.include ../../../design/netlists/ls_hv10.spice
.include ../../../design/netlists/pg_n06.spice
.include ../../../design/netlists/pg_n10.spice
.include ../../../design/netlists/band_iii.spice

X_dut RSEL_0 RSEL_1 RSEL_2 RSEL_3 CSEL_22 CSEL_23 CSEL_24 CSEL_25 CSEL_26 CSEL_27 CSEL_28 CSEL_29 CSEL_30 CSEL_31 BLG_III PLG_III VDDH_III VDDL VSS band_iii

Vddl VDDL 0 DC 3.3
Vss VSS 0 DC 0
Vrsel0 RSEL_0 0 DC 0
Vrsel1 RSEL_1 0 DC 0
Vrsel2 RSEL_2 0 DC 0
Vrsel3 RSEL_3 0 DC 0
Vcsel22 CSEL_22 0 DC 0
Vcsel23 CSEL_23 0 DC 0
Vcsel24 CSEL_24 0 DC 0
Vcsel25 CSEL_25 0 DC 0
Vcsel26 CSEL_26 0 DC 0
Vcsel27 CSEL_27 0 DC 0
Vcsel28 CSEL_28 0 DC 0
Vcsel29 CSEL_29 0 DC 0
Vcsel30 CSEL_30 0 DC 0
Vcsel31 CSEL_31 0 DC 0

Vdum NDUM 0 DC 0
Rdum NDUM 0 1k

* band rail, BLG = the assumed sense node held at the read level, PLG return
Vddh_III VDDH_III 0 DC 5.0
Vbl_III BLG_III 0 DC 0.5
Vplg_III PLG_III 0 DC 0
