* gf180-antifuse sim/array-slice-bench: slice_i_ii, process corner typical (GENERATED by make_bench.py - do not edit)
* Circuit body for `klt sim`. The MOS and moscap sections come from the request's
* corner bundle; design.ngspice (global switches) and the 10 V LDMOS library's
* matching section (typical) are resolved from $PDK_ROOT on whichever host runs the corner.
.include $PDK_ROOT/gf180mcuD/libs.tech/ngspice/design.ngspice
.lib "$PDK_ROOT/gf180mcuD/libs.tech/ngspice/smbb000149.ngspice" typical
* derived netlists of the design under test (design/netlists/, never copied)
.include ../../../design/netlists/cell_candidate1.spice
.include ../../../design/netlists/cell_candidate2.spice
.include ../../../design/netlists/cell_candidate3.spice
.include ../../../design/netlists/ls_hv06.spice
.include ../../../design/netlists/ls_hv10.spice
.include ../../../design/netlists/pg_n06.spice
.include ../../../design/netlists/pg_n10.spice
.include ../../../design/netlists/slice_i_ii.spice

X_dut RSEL_0 RSEL_1 RSEL_2 RSEL_3 CSEL_9 CSEL_10 CSEL_11 CSEL_12 BLG_I PLG_I BLG_II PLG_II VDDH_I VDDH_II VDDL VSS slice_i_ii

Vddl VDDL 0 DC 3.3
Vss VSS 0 DC 0
Vrsel0 RSEL_0 0 DC 0
Vrsel1 RSEL_1 0 DC 0
Vrsel2 RSEL_2 0 DC 0
Vrsel3 RSEL_3 0 DC 0
Vcsel9 CSEL_9 0 DC 0
Vcsel10 CSEL_10 0 DC 0
Vcsel11 CSEL_11 0 DC 0
Vcsel12 CSEL_12 0 DC 0

* dummy sweep source: the dc analysis needs a swept source with a >0-width interval so
* `.meas dc ... AT=0` has something to interpolate; it drives nothing in the design
Vdum NDUM 0 DC 0
Rdum NDUM 0 1k

* per-band rails, global bit-line bus stand-in level, return bus
Vddh_I VDDH_I 0 DC 5.0
Vbl_I BLG_I 0 DC 3.0
Vplg_I PLG_I 0 DC 0
Vddh_II VDDH_II 0 DC 5.5
Vbl_II BLG_II 0 DC 3.5
Vplg_II PLG_II 0 DC 0

* bench-only filament stand-in (1e+06 ohm) across every cell capacitor,
* with a 0 V sense source: i(vfil_<row>_<col>) is that cell's access-path current
Rfil_0_9 x_dut.xc_0_9.cn nf_0_9 1e+06
Vfil_0_9 nf_0_9 x_dut.pl_0_I 0
Rfil_0_10 x_dut.xc_0_10.cn nf_0_10 1e+06
Vfil_0_10 nf_0_10 x_dut.pl_0_I 0
Rfil_0_11 x_dut.xc_0_11.cn nf_0_11 1e+06
Vfil_0_11 nf_0_11 x_dut.pl_0_II 0
Rfil_0_12 x_dut.xc_0_12.cn nf_0_12 1e+06
Vfil_0_12 nf_0_12 x_dut.pl_0_II 0
Rfil_1_9 x_dut.xc_1_9.cn nf_1_9 1e+06
Vfil_1_9 nf_1_9 x_dut.pl_1_I 0
Rfil_1_10 x_dut.xc_1_10.cn nf_1_10 1e+06
Vfil_1_10 nf_1_10 x_dut.pl_1_I 0
Rfil_1_11 x_dut.xc_1_11.cn nf_1_11 1e+06
Vfil_1_11 nf_1_11 x_dut.pl_1_II 0
Rfil_1_12 x_dut.xc_1_12.cn nf_1_12 1e+06
Vfil_1_12 nf_1_12 x_dut.pl_1_II 0
Rfil_2_9 x_dut.xc_2_9.cn nf_2_9 1e+06
Vfil_2_9 nf_2_9 x_dut.pl_2_I 0
Rfil_2_10 x_dut.xc_2_10.cn nf_2_10 1e+06
Vfil_2_10 nf_2_10 x_dut.pl_2_I 0
Rfil_2_11 x_dut.xc_2_11.cn nf_2_11 1e+06
Vfil_2_11 nf_2_11 x_dut.pl_2_II 0
Rfil_2_12 x_dut.xc_2_12.cn nf_2_12 1e+06
Vfil_2_12 nf_2_12 x_dut.pl_2_II 0
Rfil_3_9 x_dut.xc_3_9.cn nf_3_9 1e+06
Vfil_3_9 nf_3_9 x_dut.pl_3_I 0
Rfil_3_10 x_dut.xc_3_10.cn nf_3_10 1e+06
Vfil_3_10 nf_3_10 x_dut.pl_3_I 0
Rfil_3_11 x_dut.xc_3_11.cn nf_3_11 1e+06
Vfil_3_11 nf_3_11 x_dut.pl_3_II 0
Rfil_3_12 x_dut.xc_3_12.cn nf_3_12 1e+06
Vfil_3_12 nf_3_12 x_dut.pl_3_II 0
