* gf180-antifuse sim/array-slice-bench: full-band leakage, band_ii, variant pgoff, process corner typical (GENERATED by make_bench.py - do not edit)
* Circuit body for `klt sim`. See make_bench.py (Full-band leakage) and README.md.
.include $PDK_ROOT/gf180mcuD/libs.tech/ngspice/design.ngspice
.lib "$PDK_ROOT/gf180mcuD/libs.tech/ngspice/smbb000149.ngspice" typical
* derived netlists of the design under test (design/netlists/, never copied)
.include ../../../design/netlists/cell_candidate1.spice
.include ../../../design/netlists/cell_candidate2.spice
.include ../../../design/netlists/cell_candidate3.spice
.include ../../../design/netlists/ls_hv06.spice
.include ../../../design/netlists/ls_hv10.spice
.include ../../../design/netlists/pg_n06.spice
.include ../../../design/netlists/pg_n10.spice
.include ../../../design/netlists/band_ii.spice

X_dut RSEL_0 RSEL_1 RSEL_2 RSEL_3 CSEL_11 CSEL_12 CSEL_13 CSEL_14 CSEL_15 CSEL_16 CSEL_17 CSEL_18 CSEL_19 CSEL_20 CSEL_21 BLG_II PLG_II VDDH_II VDDL VSS band_ii

Vddl VDDL 0 DC 3.3
Vss VSS 0 DC 0
Vrsel0 RSEL_0 0 DC 0
Vrsel1 RSEL_1 0 DC 0
Vrsel2 RSEL_2 0 DC 0
Vrsel3 RSEL_3 0 DC 0
Vcsel11 CSEL_11 0 DC 0
Vcsel12 CSEL_12 0 DC 0
Vcsel13 CSEL_13 0 DC 0
Vcsel14 CSEL_14 0 DC 0
Vcsel15 CSEL_15 0 DC 0
Vcsel16 CSEL_16 0 DC 0
Vcsel17 CSEL_17 0 DC 0
Vcsel18 CSEL_18 0 DC 0
Vcsel19 CSEL_19 0 DC 0
Vcsel20 CSEL_20 0 DC 0
Vcsel21 CSEL_21 0 DC 0

Vdum NDUM 0 DC 0
Rdum NDUM 0 1k

* band rail, BLG = the assumed sense node held at the read level, PLG return
Vddh_II VDDH_II 0 DC 5.5
Vbl_II BLG_II 0 DC 0.5
Vplg_II PLG_II 0 DC 0

* every BL_c clamped at 0 V: the OFF column pass-gate sees the full BLG level across
* it and the cell access devices see V_DS = 0 (cell term is NOT in this variant).
* i(vcl_<c>) = current the pass-gate delivers into BL_c (positive = out of BLG).
Vcl_11 x_dut.bl_11 0 DC 0
Vcl_12 x_dut.bl_12 0 DC 0
Vcl_13 x_dut.bl_13 0 DC 0
Vcl_14 x_dut.bl_14 0 DC 0
Vcl_15 x_dut.bl_15 0 DC 0
Vcl_16 x_dut.bl_16 0 DC 0
Vcl_17 x_dut.bl_17 0 DC 0
Vcl_18 x_dut.bl_18 0 DC 0
Vcl_19 x_dut.bl_19 0 DC 0
Vcl_20 x_dut.bl_20 0 DC 0
Vcl_21 x_dut.bl_21 0 DC 0
