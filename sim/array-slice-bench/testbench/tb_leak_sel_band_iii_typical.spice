* gf180-antifuse sim/array-slice-bench: full-band leakage, band_iii, variant sel, process corner typical (GENERATED by make_bench.py - do not edit)
* Circuit body for `klt sim`. See make_bench.py (Full-band leakage) and README.md.
.include $PDK_ROOT/gf180mcuD/libs.tech/ngspice/design.ngspice
.lib "$PDK_ROOT/gf180mcuD/libs.tech/ngspice/smbb000149.ngspice" typical
* derived netlists of the design under test (design/netlists/, never copied)
.include ../../../design/netlists/cell_candidate1.spice
.include ../../../design/netlists/cell_candidate2.spice
.include ../../../design/netlists/cell_candidate3.spice
.include ../../../design/netlists/ls_hv06.spice
.include ../../../design/netlists/ls_hv10.spice
.include ../../../design/netlists/pg_n06.spice
.include ../../../design/netlists/pg_n10.spice
.include ../../../design/netlists/band_iii.spice

X_dut RSEL_0 RSEL_1 RSEL_2 RSEL_3 CSEL_22 CSEL_23 CSEL_24 CSEL_25 CSEL_26 CSEL_27 CSEL_28 CSEL_29 CSEL_30 CSEL_31 BLG_III PLG_III VDDH_III VDDL VSS band_iii

Vddl VDDL 0 DC 3.3
Vss VSS 0 DC 0
Vrsel0 RSEL_0 0 DC 0
Vrsel1 RSEL_1 0 DC 0
Vrsel2 RSEL_2 0 DC 0
Vrsel3 RSEL_3 0 DC 0
Vcsel22 CSEL_22 0 DC 0
Vcsel23 CSEL_23 0 DC 0
Vcsel24 CSEL_24 0 DC 0
Vcsel25 CSEL_25 0 DC 0
Vcsel26 CSEL_26 0 DC 0
Vcsel27 CSEL_27 0 DC 0
Vcsel28 CSEL_28 0 DC 0
Vcsel29 CSEL_29 0 DC 0
Vcsel30 CSEL_30 0 DC 0
Vcsel31 CSEL_31 0 DC 0

Vdum NDUM 0 DC 0
Rdum NDUM 0 1k

* band rail, BLG = the assumed sense node held at the read level, PLG return
Vddh_III VDDH_III 0 DC 5.0
Vbl_III BLG_III 0 DC 0.5
Vplg_III PLG_III 0 DC 0

* bench-only filament stand-in (1e+06 ohm) across every cell capacitor (see the
* slice bench above); the selected cell's path is the read path being checked
Rfil_0_22 x_dut.xc_0_22.cn nf_0_22 1e+06
Vfil_0_22 nf_0_22 x_dut.pl_0_III 0
Rfil_0_23 x_dut.xc_0_23.cn nf_0_23 1e+06
Vfil_0_23 nf_0_23 x_dut.pl_0_III 0
Rfil_0_24 x_dut.xc_0_24.cn nf_0_24 1e+06
Vfil_0_24 nf_0_24 x_dut.pl_0_III 0
Rfil_0_25 x_dut.xc_0_25.cn nf_0_25 1e+06
Vfil_0_25 nf_0_25 x_dut.pl_0_III 0
Rfil_0_26 x_dut.xc_0_26.cn nf_0_26 1e+06
Vfil_0_26 nf_0_26 x_dut.pl_0_III 0
Rfil_0_27 x_dut.xc_0_27.cn nf_0_27 1e+06
Vfil_0_27 nf_0_27 x_dut.pl_0_III 0
Rfil_0_28 x_dut.xc_0_28.cn nf_0_28 1e+06
Vfil_0_28 nf_0_28 x_dut.pl_0_III 0
Rfil_0_29 x_dut.xc_0_29.cn nf_0_29 1e+06
Vfil_0_29 nf_0_29 x_dut.pl_0_III 0
Rfil_0_30 x_dut.xc_0_30.cn nf_0_30 1e+06
Vfil_0_30 nf_0_30 x_dut.pl_0_III 0
Rfil_0_31 x_dut.xc_0_31.cn nf_0_31 1e+06
Vfil_0_31 nf_0_31 x_dut.pl_0_III 0
Rfil_1_22 x_dut.xc_1_22.cn nf_1_22 1e+06
Vfil_1_22 nf_1_22 x_dut.pl_1_III 0
Rfil_1_23 x_dut.xc_1_23.cn nf_1_23 1e+06
Vfil_1_23 nf_1_23 x_dut.pl_1_III 0
Rfil_1_24 x_dut.xc_1_24.cn nf_1_24 1e+06
Vfil_1_24 nf_1_24 x_dut.pl_1_III 0
Rfil_1_25 x_dut.xc_1_25.cn nf_1_25 1e+06
Vfil_1_25 nf_1_25 x_dut.pl_1_III 0
Rfil_1_26 x_dut.xc_1_26.cn nf_1_26 1e+06
Vfil_1_26 nf_1_26 x_dut.pl_1_III 0
Rfil_1_27 x_dut.xc_1_27.cn nf_1_27 1e+06
Vfil_1_27 nf_1_27 x_dut.pl_1_III 0
Rfil_1_28 x_dut.xc_1_28.cn nf_1_28 1e+06
Vfil_1_28 nf_1_28 x_dut.pl_1_III 0
Rfil_1_29 x_dut.xc_1_29.cn nf_1_29 1e+06
Vfil_1_29 nf_1_29 x_dut.pl_1_III 0
Rfil_1_30 x_dut.xc_1_30.cn nf_1_30 1e+06
Vfil_1_30 nf_1_30 x_dut.pl_1_III 0
Rfil_1_31 x_dut.xc_1_31.cn nf_1_31 1e+06
Vfil_1_31 nf_1_31 x_dut.pl_1_III 0
Rfil_2_22 x_dut.xc_2_22.cn nf_2_22 1e+06
Vfil_2_22 nf_2_22 x_dut.pl_2_III 0
Rfil_2_23 x_dut.xc_2_23.cn nf_2_23 1e+06
Vfil_2_23 nf_2_23 x_dut.pl_2_III 0
Rfil_2_24 x_dut.xc_2_24.cn nf_2_24 1e+06
Vfil_2_24 nf_2_24 x_dut.pl_2_III 0
Rfil_2_25 x_dut.xc_2_25.cn nf_2_25 1e+06
Vfil_2_25 nf_2_25 x_dut.pl_2_III 0
Rfil_2_26 x_dut.xc_2_26.cn nf_2_26 1e+06
Vfil_2_26 nf_2_26 x_dut.pl_2_III 0
Rfil_2_27 x_dut.xc_2_27.cn nf_2_27 1e+06
Vfil_2_27 nf_2_27 x_dut.pl_2_III 0
Rfil_2_28 x_dut.xc_2_28.cn nf_2_28 1e+06
Vfil_2_28 nf_2_28 x_dut.pl_2_III 0
Rfil_2_29 x_dut.xc_2_29.cn nf_2_29 1e+06
Vfil_2_29 nf_2_29 x_dut.pl_2_III 0
Rfil_2_30 x_dut.xc_2_30.cn nf_2_30 1e+06
Vfil_2_30 nf_2_30 x_dut.pl_2_III 0
Rfil_2_31 x_dut.xc_2_31.cn nf_2_31 1e+06
Vfil_2_31 nf_2_31 x_dut.pl_2_III 0
Rfil_3_22 x_dut.xc_3_22.cn nf_3_22 1e+06
Vfil_3_22 nf_3_22 x_dut.pl_3_III 0
Rfil_3_23 x_dut.xc_3_23.cn nf_3_23 1e+06
Vfil_3_23 nf_3_23 x_dut.pl_3_III 0
Rfil_3_24 x_dut.xc_3_24.cn nf_3_24 1e+06
Vfil_3_24 nf_3_24 x_dut.pl_3_III 0
Rfil_3_25 x_dut.xc_3_25.cn nf_3_25 1e+06
Vfil_3_25 nf_3_25 x_dut.pl_3_III 0
Rfil_3_26 x_dut.xc_3_26.cn nf_3_26 1e+06
Vfil_3_26 nf_3_26 x_dut.pl_3_III 0
Rfil_3_27 x_dut.xc_3_27.cn nf_3_27 1e+06
Vfil_3_27 nf_3_27 x_dut.pl_3_III 0
Rfil_3_28 x_dut.xc_3_28.cn nf_3_28 1e+06
Vfil_3_28 nf_3_28 x_dut.pl_3_III 0
Rfil_3_29 x_dut.xc_3_29.cn nf_3_29 1e+06
Vfil_3_29 nf_3_29 x_dut.pl_3_III 0
Rfil_3_30 x_dut.xc_3_30.cn nf_3_30 1e+06
Vfil_3_30 nf_3_30 x_dut.pl_3_III 0
Rfil_3_31 x_dut.xc_3_31.cn nf_3_31 1e+06
Vfil_3_31 nf_3_31 x_dut.pl_3_III 0
