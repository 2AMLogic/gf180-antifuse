* gf180-antifuse sim/array-slice-bench: full-band leakage, band_ii, variant sel, process corner typical (GENERATED by make_bench.py - do not edit)
* Circuit body for `klt sim`. See make_bench.py (Full-band leakage) and README.md.
.include $PDK_ROOT/gf180mcuD/libs.tech/ngspice/design.ngspice
.lib "$PDK_ROOT/gf180mcuD/libs.tech/ngspice/smbb000149.ngspice" typical
* derived netlists of the design under test (design/netlists/, never copied)
.include ../../../design/netlists/cell_candidate1.spice
.include ../../../design/netlists/cell_candidate2.spice
.include ../../../design/netlists/cell_candidate3.spice
.include ../../../design/netlists/ls_hv06.spice
.include ../../../design/netlists/ls_hv10.spice
.include ../../../design/netlists/pg_n06.spice
.include ../../../design/netlists/pg_n10.spice
.include ../../../design/netlists/band_ii.spice

X_dut RSEL_0 RSEL_1 RSEL_2 RSEL_3 CSEL_11 CSEL_12 CSEL_13 CSEL_14 CSEL_15 CSEL_16 CSEL_17 CSEL_18 CSEL_19 CSEL_20 CSEL_21 BLG_II PLG_II VDDH_II VDDL VSS band_ii

Vddl VDDL 0 DC 3.3
Vss VSS 0 DC 0
Vrsel0 RSEL_0 0 DC 0
Vrsel1 RSEL_1 0 DC 0
Vrsel2 RSEL_2 0 DC 0
Vrsel3 RSEL_3 0 DC 0
Vcsel11 CSEL_11 0 DC 0
Vcsel12 CSEL_12 0 DC 0
Vcsel13 CSEL_13 0 DC 0
Vcsel14 CSEL_14 0 DC 0
Vcsel15 CSEL_15 0 DC 0
Vcsel16 CSEL_16 0 DC 0
Vcsel17 CSEL_17 0 DC 0
Vcsel18 CSEL_18 0 DC 0
Vcsel19 CSEL_19 0 DC 0
Vcsel20 CSEL_20 0 DC 0
Vcsel21 CSEL_21 0 DC 0

Vdum NDUM 0 DC 0
Rdum NDUM 0 1k

* band rail, BLG = the assumed sense node held at the read level, PLG return
Vddh_II VDDH_II 0 DC 5.5
Vbl_II BLG_II 0 DC 0.5
Vplg_II PLG_II 0 DC 0

* bench-only filament stand-in (1e+06 ohm) across every cell capacitor (see the
* slice bench above); the selected cell's path is the read path being checked
Rfil_0_11 x_dut.xc_0_11.cn nf_0_11 1e+06
Vfil_0_11 nf_0_11 x_dut.pl_0_II 0
Rfil_0_12 x_dut.xc_0_12.cn nf_0_12 1e+06
Vfil_0_12 nf_0_12 x_dut.pl_0_II 0
Rfil_0_13 x_dut.xc_0_13.cn nf_0_13 1e+06
Vfil_0_13 nf_0_13 x_dut.pl_0_II 0
Rfil_0_14 x_dut.xc_0_14.cn nf_0_14 1e+06
Vfil_0_14 nf_0_14 x_dut.pl_0_II 0
Rfil_0_15 x_dut.xc_0_15.cn nf_0_15 1e+06
Vfil_0_15 nf_0_15 x_dut.pl_0_II 0
Rfil_0_16 x_dut.xc_0_16.cn nf_0_16 1e+06
Vfil_0_16 nf_0_16 x_dut.pl_0_II 0
Rfil_0_17 x_dut.xc_0_17.cn nf_0_17 1e+06
Vfil_0_17 nf_0_17 x_dut.pl_0_II 0
Rfil_0_18 x_dut.xc_0_18.cn nf_0_18 1e+06
Vfil_0_18 nf_0_18 x_dut.pl_0_II 0
Rfil_0_19 x_dut.xc_0_19.cn nf_0_19 1e+06
Vfil_0_19 nf_0_19 x_dut.pl_0_II 0
Rfil_0_20 x_dut.xc_0_20.cn nf_0_20 1e+06
Vfil_0_20 nf_0_20 x_dut.pl_0_II 0
Rfil_0_21 x_dut.xc_0_21.cn nf_0_21 1e+06
Vfil_0_21 nf_0_21 x_dut.pl_0_II 0
Rfil_1_11 x_dut.xc_1_11.cn nf_1_11 1e+06
Vfil_1_11 nf_1_11 x_dut.pl_1_II 0
Rfil_1_12 x_dut.xc_1_12.cn nf_1_12 1e+06
Vfil_1_12 nf_1_12 x_dut.pl_1_II 0
Rfil_1_13 x_dut.xc_1_13.cn nf_1_13 1e+06
Vfil_1_13 nf_1_13 x_dut.pl_1_II 0
Rfil_1_14 x_dut.xc_1_14.cn nf_1_14 1e+06
Vfil_1_14 nf_1_14 x_dut.pl_1_II 0
Rfil_1_15 x_dut.xc_1_15.cn nf_1_15 1e+06
Vfil_1_15 nf_1_15 x_dut.pl_1_II 0
Rfil_1_16 x_dut.xc_1_16.cn nf_1_16 1e+06
Vfil_1_16 nf_1_16 x_dut.pl_1_II 0
Rfil_1_17 x_dut.xc_1_17.cn nf_1_17 1e+06
Vfil_1_17 nf_1_17 x_dut.pl_1_II 0
Rfil_1_18 x_dut.xc_1_18.cn nf_1_18 1e+06
Vfil_1_18 nf_1_18 x_dut.pl_1_II 0
Rfil_1_19 x_dut.xc_1_19.cn nf_1_19 1e+06
Vfil_1_19 nf_1_19 x_dut.pl_1_II 0
Rfil_1_20 x_dut.xc_1_20.cn nf_1_20 1e+06
Vfil_1_20 nf_1_20 x_dut.pl_1_II 0
Rfil_1_21 x_dut.xc_1_21.cn nf_1_21 1e+06
Vfil_1_21 nf_1_21 x_dut.pl_1_II 0
Rfil_2_11 x_dut.xc_2_11.cn nf_2_11 1e+06
Vfil_2_11 nf_2_11 x_dut.pl_2_II 0
Rfil_2_12 x_dut.xc_2_12.cn nf_2_12 1e+06
Vfil_2_12 nf_2_12 x_dut.pl_2_II 0
Rfil_2_13 x_dut.xc_2_13.cn nf_2_13 1e+06
Vfil_2_13 nf_2_13 x_dut.pl_2_II 0
Rfil_2_14 x_dut.xc_2_14.cn nf_2_14 1e+06
Vfil_2_14 nf_2_14 x_dut.pl_2_II 0
Rfil_2_15 x_dut.xc_2_15.cn nf_2_15 1e+06
Vfil_2_15 nf_2_15 x_dut.pl_2_II 0
Rfil_2_16 x_dut.xc_2_16.cn nf_2_16 1e+06
Vfil_2_16 nf_2_16 x_dut.pl_2_II 0
Rfil_2_17 x_dut.xc_2_17.cn nf_2_17 1e+06
Vfil_2_17 nf_2_17 x_dut.pl_2_II 0
Rfil_2_18 x_dut.xc_2_18.cn nf_2_18 1e+06
Vfil_2_18 nf_2_18 x_dut.pl_2_II 0
Rfil_2_19 x_dut.xc_2_19.cn nf_2_19 1e+06
Vfil_2_19 nf_2_19 x_dut.pl_2_II 0
Rfil_2_20 x_dut.xc_2_20.cn nf_2_20 1e+06
Vfil_2_20 nf_2_20 x_dut.pl_2_II 0
Rfil_2_21 x_dut.xc_2_21.cn nf_2_21 1e+06
Vfil_2_21 nf_2_21 x_dut.pl_2_II 0
Rfil_3_11 x_dut.xc_3_11.cn nf_3_11 1e+06
Vfil_3_11 nf_3_11 x_dut.pl_3_II 0
Rfil_3_12 x_dut.xc_3_12.cn nf_3_12 1e+06
Vfil_3_12 nf_3_12 x_dut.pl_3_II 0
Rfil_3_13 x_dut.xc_3_13.cn nf_3_13 1e+06
Vfil_3_13 nf_3_13 x_dut.pl_3_II 0
Rfil_3_14 x_dut.xc_3_14.cn nf_3_14 1e+06
Vfil_3_14 nf_3_14 x_dut.pl_3_II 0
Rfil_3_15 x_dut.xc_3_15.cn nf_3_15 1e+06
Vfil_3_15 nf_3_15 x_dut.pl_3_II 0
Rfil_3_16 x_dut.xc_3_16.cn nf_3_16 1e+06
Vfil_3_16 nf_3_16 x_dut.pl_3_II 0
Rfil_3_17 x_dut.xc_3_17.cn nf_3_17 1e+06
Vfil_3_17 nf_3_17 x_dut.pl_3_II 0
Rfil_3_18 x_dut.xc_3_18.cn nf_3_18 1e+06
Vfil_3_18 nf_3_18 x_dut.pl_3_II 0
Rfil_3_19 x_dut.xc_3_19.cn nf_3_19 1e+06
Vfil_3_19 nf_3_19 x_dut.pl_3_II 0
Rfil_3_20 x_dut.xc_3_20.cn nf_3_20 1e+06
Vfil_3_20 nf_3_20 x_dut.pl_3_II 0
Rfil_3_21 x_dut.xc_3_21.cn nf_3_21 1e+06
Vfil_3_21 nf_3_21 x_dut.pl_3_II 0
