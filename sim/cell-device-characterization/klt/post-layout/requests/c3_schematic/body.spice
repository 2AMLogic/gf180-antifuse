* GENERATED by klt/post-layout/mk_post_layout_requests.py -- do not edit.
* Candidate 3 (Region III) post-layout access-device probe,
* schematic leg (issue #447).  Circuit body for `klt sim`: models/.temp/analysis
* are supplied by the request.  DUT include: ../../../../../../layout/cell_candidate3/lvs_reference.spice
.include "../design.ngspice"
.include "../../../../../../layout/cell_candidate3/lvs_reference.spice"
.options gmin=1.000000e-13
X1 BL WL PL VB cell_candidate3
VVB VB 0 DC 3.300000e+00
VBL BL 0 DC 1.000000e+00 AC 1
VWL WL 0 DC 0.000000e+00
VPL PL 0 DC 0
