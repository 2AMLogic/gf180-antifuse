* GENERATED by klt/mk_klt_requests.py -- do not edit.
* Candidate 3 (Region III), access-min_cap-min.
* Circuit body for `klt sim`: models/.temp/analysis are supplied by the request.
.include "../design.ngspice"
.include "../../../../../design/netlists/cell_candidate3.spice"
.options gmin=1.000000e-13
X1 BL WL PL VB cell_candidate3 wcap=1.000000e-06 lcap=1.000000e-06 wacc=3.000000e-07 lacc=5.500000e-07
VVB VB 0 DC 3.300000e+00
VBL BL 0 DC 1.000000e+00 AC 1
VWL WL 0 DC 0.000000e+00
VPL PL 0 DC 0
