* gf180-antifuse sim/hv-pad-protection -- Candidate 1 bench nbd_f (tran, #210)
* Generated by run_experiment.py; frozen here as evidence. See README.
* --- inlined from gf180mcuD/libs.tech/ngspice/design.ngspice (sha256 7e222f050318388f37543a64fbd0be55cc15e4b93f57501a09f7c159c4c9e561) ---
.param sw_stat_global=0
.param sw_stat_mismatch=0
.param mc_skew=3
.param res_mc_skew=3
.param cap_mc_skew=3
.param fnoicor=0
* --- end inline ---
.options gmin=1.000000e-13
.param t1=1.000000e-06 tr=1.000000e-07 tw=2.000000e-06
.func af_fe(u) {exp(-1/max(u,1e-6))}
.func af_edge(x) {af_fe(min(max(x,0),1))/(af_fe(min(max(x,0),1))+af_fe(1-min(max(x,0),1)))}
BSH SH 0 V = 'af_edge((time-t1)/tr) - af_edge((time-t1-tr-tw)/tr)'
* --- inlined from design/hv-pad/hv_pad_path.spice (sha256 695a1f81cd8483f44a8877598638298cc0f0433964df915aa7af7a1fe29210c6) ---
* gf180-antifuse: program-voltage (PL) pad paths for the Run 3 direct-pad chip
* (issue #210, part of #203). Hand-written netlist, no xschem schematic: every
* path below is two passive elements at most. Evidence and decision:
* spec/hv-pad-protection-decision.md, sim/hv-pad-protection/.
*
* The sim runner (sim/hv-pad-protection/run_experiment.py) reads this file at
* run time and inlines it into each batch deck; nothing here is copied by hand.
*
* Three paths from the bond pad PAD to the cell's private plate node PL:
*
*   std_pad_asig5v   REJECTED. The ESD diodes of the standard analog pad cell
*                    gf180mcu_fd_io__asig_5p0, copied VERBATIM from
*                    libs.ref/gf180mcu_fd_io/spice/gf180mcu_fd_io.spice (the
*                    decoupling cap D0/X1 is omitted: it is not on the pad).
*                    Both diodes are to the shared DVDD / DVSS rails.
*   hv_pad_direct    REJECTED. Bare pad wired straight to PL. No device.
*   hv_pad_ballast   CHOSEN. Bare pad (no pad cell, no connection to any shared
*                    rail), one series ppolyf_u_2k_6p0 per PL, at the geometry
*                    of the committed program-leg ballast (design/netlists/
*                    program_leg.spice: rb_w = 2u, rb_l = 7.5u). Its voltage
*                    rating is OPEN (spec/leg-design-record.md section 3).

* Standard pad cell: PAD to DVSS and PAD to DVDD clamp diodes (verbatim).
.subckt std_pad_asig5v PAD DVDD DVSS
D2 DVSS PAD diode_nd2ps_06v0 m=4.0 area=150e-12 pj=106e-6
D3 PAD DVDD diode_pd2nw_06v0 m=4.0 area=150e-12 pj=106e-6
.ends std_pad_asig5v

* Bare pad wired to the plate: the two names are one node. A 0 V source keeps
* the pad current measurable as i(VPADI).
.subckt hv_pad_direct PAD PL
VPADI PAD PL DC 0
.ends hv_pad_direct

* Bare pad, series ballast to the plate. VSS is the resistor's body terminal.
.subckt hv_pad_ballast PAD PL VSS rb_w=2u rb_l=7.5u
XRB PAD PL VSS ppolyf_u_2k_6p0 r_width=rb_w r_length=rb_l m=1
.ends hv_pad_ballast
* --- end inline ---
.model SBD SW(vt=4.400000e+00 vh=3.600000e+00 ron=1.0e-3 roff=1.0e9)
VAMP AMP 0 DC 0
BVPP VPP 0 V = 'v(amp)*v(sh)'
CPD PAD 0 1.000000e-12
VBL BL 0 DC 0
CPL PL 0 1.000000e-13
RSRC VPP VCAB 1.000000e+02
CCAB VCAB 0 1.000000e-10
REXT VCAB PAD 1.000000e+04
BIP IPD 0 V = '(v(vpp)-v(vcab))/1.000000e+02'
XPD PAD PL hv_pad_direct
XC CN PL cap_nmos_03v3 c_width=1.000000e-06 c_length=1.000000e-06
RACC CN BL 1.000000e+03
S PL NF PL CN SBD
RF NF CN 1.000000e+04
BIF IFIL 0 V = 'abs(v(nf)-v(cn))/1.000000e+04'
BOX DOX 0 V = 'abs(v(PL)-v(cn))'
BAP APAD 0 V = 'abs(v(pad))'
BAL APL 0 V = 'abs(v(pl))'
XPDJ PADJ PLJ hv_pad_direct
CPDJ PADJ 0 1.000000e-12
CPLJ PLJ 0 1.000000e-13
CCPL PL PLJ 1.000000e-13
VNJ NJ 0 DC 0
RSRCJ NJ VCABJ 1.000000e+02
CCABJ VCABJ 0 1.000000e-10
REXTJ VCABJ PADJ 1.000000e+04
XCJ CNJ PLJ cap_nmos_03v3 c_width=1.000000e-06 c_length=1.000000e-06
RACCJ CNJ BL 1.000000e+03
SJ PLJ NFJ PLJ CNJ SBD
RFJ NFJ CNJ 1.000000e+04
BIFJ IFILJ 0 V = 'abs(v(nfJ)-v(cnJ))/1.000000e+04'
BOXJ DOXJ 0 V = 'abs(v(PLJ)-v(cnJ))'
