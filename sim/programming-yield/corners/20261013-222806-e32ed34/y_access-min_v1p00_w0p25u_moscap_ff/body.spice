* gf180-antifuse sim/cell-breakdown-model -- Candidate 2 programming-yield bench (tran), access min, tw=2.5e-07
* Generated by run_experiment.py; frozen here as evidence. See README.
* --- inlined from gf180mcuD/libs.tech/ngspice/design.ngspice (sha256 091cb530bf85160a1f07878fb81f789ca367d018991c8ab41a584cd1a85c6692) ---
.param
+  sw_stat_global = 0
+  sw_stat_mismatch = 0
+ mc_skew = 3
+ res_mc_skew = 3
+ cap_mc_skew = 3
+  fnoicor = 0
* --- end inline ---
.lib /opt/pdk/gf180mcuD/libs.tech/ngspice/smbb000149.ngspice typical
.options gmin=1.000000e-13
.include ../../../../../design/breakdown/cell_candidates_bd.spice

.param t1=1.000000e-06 tr=1.000000e-07 tw=2.500000e-07
.param ubd_s={min(max(aunif(0.5,0.5),1e-06),0.999999)}
.param zrf_s={agauss(0,1,1)}
VBL BL 0 DC 0
VWL WL 0 DC 5.000000e+00
VVB VB 0 DC 0.000000e+00
BSH SH 0 V = '0.5*(1-cos(pi*min(max((time-t1)/tr,0),1))) - 0.5*(1-cos(pi*min(max((time-t1-tr-tw)/tr,0),1)))'
VAMP AMP 0 DC 0
BPL PL 0 V = 'v(amp)*v(sh)'
XA BL WL PL VB cell_candidate2_bd wcap=1.000000e-06 lcap=1.000000e-06 wacc=2.500000e-05 lacc=6.000000e-07 bden=1 prog=0 dyn=1 ubd={ubd_s} zrf={zrf_s}
