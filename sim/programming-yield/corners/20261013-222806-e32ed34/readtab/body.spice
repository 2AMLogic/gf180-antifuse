* gf180-antifuse sim/cell-breakdown-model -- Candidate 2 programmed-read table (z grid)
* Generated by run_experiment.py; frozen here as evidence. See README.
* --- inlined from gf180mcuD/libs.tech/ngspice/design.ngspice (sha256 091cb530bf85160a1f07878fb81f789ca367d018991c8ab41a584cd1a85c6692) ---
.param
+  sw_stat_global = 0
+  sw_stat_mismatch = 0
+ mc_skew = 3
+ res_mc_skew = 3
+ cap_mc_skew = 3
+  fnoicor = 0
* --- end inline ---
.lib /opt/pdk/gf180mcuD/libs.tech/ngspice/sm141064.ngspice moscap_typical
.options gmin=1.000000e-13
.include ../../../../../design/breakdown/cell_candidates_bd.spice

VBL BL 0 DC 1.000000e+00
VVB VB 0 DC 0.000000e+00
VPL PL 0 DC 0
VDMY DMY 0 DC 0
VWLON WLON 0 DC 5.000000e+00
VM_min_zm3 BL B_min_zm3 0
X_min_zm3 B_min_zm3 WLON PL VB cell_candidate2_bd wcap=1.000000e-06 lcap=1.000000e-06 wacc=2.500000e-05 lacc=6.000000e-07 bden=1 prog=1 dyn=0 zrf=-3
VM_min_zm2 BL B_min_zm2 0
X_min_zm2 B_min_zm2 WLON PL VB cell_candidate2_bd wcap=1.000000e-06 lcap=1.000000e-06 wacc=2.500000e-05 lacc=6.000000e-07 bden=1 prog=1 dyn=0 zrf=-2
VM_min_zm1 BL B_min_zm1 0
X_min_zm1 B_min_zm1 WLON PL VB cell_candidate2_bd wcap=1.000000e-06 lcap=1.000000e-06 wacc=2.500000e-05 lacc=6.000000e-07 bden=1 prog=1 dyn=0 zrf=-1
VM_min_zp0 BL B_min_zp0 0
X_min_zp0 B_min_zp0 WLON PL VB cell_candidate2_bd wcap=1.000000e-06 lcap=1.000000e-06 wacc=2.500000e-05 lacc=6.000000e-07 bden=1 prog=1 dyn=0 zrf=0
VM_min_zp1 BL B_min_zp1 0
X_min_zp1 B_min_zp1 WLON PL VB cell_candidate2_bd wcap=1.000000e-06 lcap=1.000000e-06 wacc=2.500000e-05 lacc=6.000000e-07 bden=1 prog=1 dyn=0 zrf=1
VM_min_zp2 BL B_min_zp2 0
X_min_zp2 B_min_zp2 WLON PL VB cell_candidate2_bd wcap=1.000000e-06 lcap=1.000000e-06 wacc=2.500000e-05 lacc=6.000000e-07 bden=1 prog=1 dyn=0 zrf=2
VM_min_zp3 BL B_min_zp3 0
X_min_zp3 B_min_zp3 WLON PL VB cell_candidate2_bd wcap=1.000000e-06 lcap=1.000000e-06 wacc=2.500000e-05 lacc=6.000000e-07 bden=1 prog=1 dyn=0 zrf=3
VM_min_zp4 BL B_min_zp4 0
X_min_zp4 B_min_zp4 WLON PL VB cell_candidate2_bd wcap=1.000000e-06 lcap=1.000000e-06 wacc=2.500000e-05 lacc=6.000000e-07 bden=1 prog=1 dyn=0 zrf=4
VM_2x_zm3 BL B_2x_zm3 0
X_2x_zm3 B_2x_zm3 WLON PL VB cell_candidate2_bd wcap=1.000000e-06 lcap=1.000000e-06 wacc=5.000000e-05 lacc=6.000000e-07 bden=1 prog=1 dyn=0 zrf=-3
VM_2x_zm2 BL B_2x_zm2 0
X_2x_zm2 B_2x_zm2 WLON PL VB cell_candidate2_bd wcap=1.000000e-06 lcap=1.000000e-06 wacc=5.000000e-05 lacc=6.000000e-07 bden=1 prog=1 dyn=0 zrf=-2
VM_2x_zm1 BL B_2x_zm1 0
X_2x_zm1 B_2x_zm1 WLON PL VB cell_candidate2_bd wcap=1.000000e-06 lcap=1.000000e-06 wacc=5.000000e-05 lacc=6.000000e-07 bden=1 prog=1 dyn=0 zrf=-1
VM_2x_zp0 BL B_2x_zp0 0
X_2x_zp0 B_2x_zp0 WLON PL VB cell_candidate2_bd wcap=1.000000e-06 lcap=1.000000e-06 wacc=5.000000e-05 lacc=6.000000e-07 bden=1 prog=1 dyn=0 zrf=0
VM_2x_zp1 BL B_2x_zp1 0
X_2x_zp1 B_2x_zp1 WLON PL VB cell_candidate2_bd wcap=1.000000e-06 lcap=1.000000e-06 wacc=5.000000e-05 lacc=6.000000e-07 bden=1 prog=1 dyn=0 zrf=1
VM_2x_zp2 BL B_2x_zp2 0
X_2x_zp2 B_2x_zp2 WLON PL VB cell_candidate2_bd wcap=1.000000e-06 lcap=1.000000e-06 wacc=5.000000e-05 lacc=6.000000e-07 bden=1 prog=1 dyn=0 zrf=2
VM_2x_zp3 BL B_2x_zp3 0
X_2x_zp3 B_2x_zp3 WLON PL VB cell_candidate2_bd wcap=1.000000e-06 lcap=1.000000e-06 wacc=5.000000e-05 lacc=6.000000e-07 bden=1 prog=1 dyn=0 zrf=3
VM_2x_zp4 BL B_2x_zp4 0
X_2x_zp4 B_2x_zp4 WLON PL VB cell_candidate2_bd wcap=1.000000e-06 lcap=1.000000e-06 wacc=5.000000e-05 lacc=6.000000e-07 bden=1 prog=1 dyn=0 zrf=4
