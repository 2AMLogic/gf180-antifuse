* gf180-antifuse sim/program-read-legs -- margin bench, Candidate 3 (Region III)
* GENERATED by sim/program-read-legs/benches.py -- do not edit.
* Netlist body for klt sim: no .control/.end (klt appends them).
.include ../../../design/netlists/leg_interlock.spice
.include ../../../design/netlists/program_leg.spice
.include ../../../design/netlists/read_leg.spice
.include ../../../design/netlists/cell_candidate3.spice
VDD vdd 0 DC 3.300000e+00
VCLAMP vclamp 0 DC 1.800000e+00
* logic highs track VDD (E sources) so the corner's VDD moves them too
EHI hi 0 vdd 0 1
VPL pl 0 DC 0
VWL wl 0 DC 0
EVB vb 0 hi 0 1
VPPIDLE vppi 0 DC 6.000000e+00
* read leg enabled (READ_EN=1, PROG_EN=0); program leg present but OFF
EREN read_en 0 hi 0 1
VPEN prog_en 0 DC 0
* ---- instance U_min: side=U access sizing=min ----
XC_U_min bl_U_min wl pl vb cell_candidate3 wacc=3.000000e-07
ISNK_U_min bl_U_min 0 DC 1.395600e-11
VAMR_U_min blr_U_min bl_U_min DC 0
VAMP_U_min blp_U_min bl_U_min DC 0
XRD_U_min prog_en read_en vclamp iref_U_min vdd 0 blr_U_min sense_U_min rdata_U_min read_leg
XPG_U_min prog_en read_en vdd 0 blp_U_min vppi program_leg
IREF_U_min 0 iref_U_min DC 3.000000e-10
* ---- instance U_2x: side=U access sizing=2x ----
XC_U_2x bl_U_2x wl pl vb cell_candidate3 wacc=6.000000e-07
ISNK_U_2x bl_U_2x 0 DC 1.395600e-11
VAMR_U_2x blr_U_2x bl_U_2x DC 0
VAMP_U_2x blp_U_2x bl_U_2x DC 0
XRD_U_2x prog_en read_en vclamp iref_U_2x vdd 0 blr_U_2x sense_U_2x rdata_U_2x read_leg
XPG_U_2x prog_en read_en vdd 0 blp_U_2x vppi program_leg
IREF_U_2x 0 iref_U_2x DC 3.000000e-10
* ---- instance Plo_min: side=Plo access sizing=min ----
XC_Plo_min bl_Plo_min wl pl vb cell_candidate3 wacc=3.000000e-07
RPRG_Plo_min xc_Plo_min.cn pl 1.000000e+04
ISNK_Plo_min bl_Plo_min 0 DC 1.395600e-11
VAMR_Plo_min blr_Plo_min bl_Plo_min DC 0
VAMP_Plo_min blp_Plo_min bl_Plo_min DC 0
XRD_Plo_min prog_en read_en vclamp iref_Plo_min vdd 0 blr_Plo_min sense_Plo_min rdata_Plo_min read_leg
XPG_Plo_min prog_en read_en vdd 0 blp_Plo_min vppi program_leg
IREF_Plo_min 0 iref_Plo_min DC 3.000000e-10
* ---- instance Plo_2x: side=Plo access sizing=2x ----
XC_Plo_2x bl_Plo_2x wl pl vb cell_candidate3 wacc=6.000000e-07
RPRG_Plo_2x xc_Plo_2x.cn pl 1.000000e+04
ISNK_Plo_2x bl_Plo_2x 0 DC 1.395600e-11
VAMR_Plo_2x blr_Plo_2x bl_Plo_2x DC 0
VAMP_Plo_2x blp_Plo_2x bl_Plo_2x DC 0
XRD_Plo_2x prog_en read_en vclamp iref_Plo_2x vdd 0 blr_Plo_2x sense_Plo_2x rdata_Plo_2x read_leg
XPG_Plo_2x prog_en read_en vdd 0 blp_Plo_2x vppi program_leg
IREF_Plo_2x 0 iref_Plo_2x DC 3.000000e-10
* ---- instance Phi_min: side=Phi access sizing=min ----
XC_Phi_min bl_Phi_min wl pl vb cell_candidate3 wacc=3.000000e-07
RPRG_Phi_min xc_Phi_min.cn pl 1.000000e+05
ISNK_Phi_min bl_Phi_min 0 DC 1.395600e-11
VAMR_Phi_min blr_Phi_min bl_Phi_min DC 0
VAMP_Phi_min blp_Phi_min bl_Phi_min DC 0
XRD_Phi_min prog_en read_en vclamp iref_Phi_min vdd 0 blr_Phi_min sense_Phi_min rdata_Phi_min read_leg
XPG_Phi_min prog_en read_en vdd 0 blp_Phi_min vppi program_leg
IREF_Phi_min 0 iref_Phi_min DC 3.000000e-10
* ---- instance Phi_2x: side=Phi access sizing=2x ----
XC_Phi_2x bl_Phi_2x wl pl vb cell_candidate3 wacc=6.000000e-07
RPRG_Phi_2x xc_Phi_2x.cn pl 1.000000e+05
ISNK_Phi_2x bl_Phi_2x 0 DC 1.395600e-11
VAMR_Phi_2x blr_Phi_2x bl_Phi_2x DC 0
VAMP_Phi_2x blp_Phi_2x bl_Phi_2x DC 0
XRD_Phi_2x prog_en read_en vclamp iref_Phi_2x vdd 0 blr_Phi_2x sense_Phi_2x rdata_Phi_2x read_leg
XPG_Phi_2x prog_en read_en vdd 0 blp_Phi_2x vppi program_leg
IREF_Phi_2x 0 iref_Phi_2x DC 3.000000e-10
