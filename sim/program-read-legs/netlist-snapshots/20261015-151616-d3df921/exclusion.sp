* gf180-antifuse sim/program-read-legs -- mutual-exclusion bench (both legs on one bit line)
* GENERATED by sim/program-read-legs/benches.py -- do not edit.
* Netlist body for klt sim: no .control/.end (klt appends them).
.include ../../../design/netlists/leg_interlock.spice
.include ../../../design/netlists/program_leg.spice
.include ../../../design/netlists/read_leg.spice
VDD vdd 0 DC 3.300000e+00
VCLAMP vclamp 0 DC 1.800000e+00
* logic highs track VDD (E sources) so the corner's VDD moves them too
EHI hi 0 vdd 0 1
* BL driven at 0 V (legs would SOURCE current) or at VPP (legs would SINK it)
* ---- p0r0_vpp3p63_bl0 ----
VPP_p0r0_vpp3p63_bl0 vpp_p0r0_vpp3p63_bl0 0 DC 3.630000e+00
VBL_p0r0_vpp3p63_bl0 bl_p0r0_vpp3p63_bl0 0 DC 0.000000e+00
VPEN_p0r0_vpp3p63_bl0 pen_p0r0_vpp3p63_bl0 0 DC 0
VREN_p0r0_vpp3p63_bl0 ren_p0r0_vpp3p63_bl0 0 DC 0
VAMP_p0r0_vpp3p63_bl0 blp_p0r0_vpp3p63_bl0 bl_p0r0_vpp3p63_bl0 DC 0
VAMR_p0r0_vpp3p63_bl0 blr_p0r0_vpp3p63_bl0 bl_p0r0_vpp3p63_bl0 DC 0
XPG_p0r0_vpp3p63_bl0 pen_p0r0_vpp3p63_bl0 ren_p0r0_vpp3p63_bl0 vdd 0 blp_p0r0_vpp3p63_bl0 vpp_p0r0_vpp3p63_bl0 program_leg
XRD_p0r0_vpp3p63_bl0 pen_p0r0_vpp3p63_bl0 ren_p0r0_vpp3p63_bl0 vclamp iref_p0r0_vpp3p63_bl0 vdd 0 blr_p0r0_vpp3p63_bl0 sense_p0r0_vpp3p63_bl0 rdata_p0r0_vpp3p63_bl0 read_leg
IREF_p0r0_vpp3p63_bl0 0 iref_p0r0_vpp3p63_bl0 DC 1.000000e-06
* ---- p0r0_vpp3p63_blvpp ----
VPP_p0r0_vpp3p63_blvpp vpp_p0r0_vpp3p63_blvpp 0 DC 3.630000e+00
VBL_p0r0_vpp3p63_blvpp bl_p0r0_vpp3p63_blvpp 0 DC 3.630000e+00
VPEN_p0r0_vpp3p63_blvpp pen_p0r0_vpp3p63_blvpp 0 DC 0
VREN_p0r0_vpp3p63_blvpp ren_p0r0_vpp3p63_blvpp 0 DC 0
VAMP_p0r0_vpp3p63_blvpp blp_p0r0_vpp3p63_blvpp bl_p0r0_vpp3p63_blvpp DC 0
VAMR_p0r0_vpp3p63_blvpp blr_p0r0_vpp3p63_blvpp bl_p0r0_vpp3p63_blvpp DC 0
XPG_p0r0_vpp3p63_blvpp pen_p0r0_vpp3p63_blvpp ren_p0r0_vpp3p63_blvpp vdd 0 blp_p0r0_vpp3p63_blvpp vpp_p0r0_vpp3p63_blvpp program_leg
XRD_p0r0_vpp3p63_blvpp pen_p0r0_vpp3p63_blvpp ren_p0r0_vpp3p63_blvpp vclamp iref_p0r0_vpp3p63_blvpp vdd 0 blr_p0r0_vpp3p63_blvpp sense_p0r0_vpp3p63_blvpp rdata_p0r0_vpp3p63_blvpp read_leg
IREF_p0r0_vpp3p63_blvpp 0 iref_p0r0_vpp3p63_blvpp DC 1.000000e-06
* ---- p0r0_vpp6p00_bl0 ----
VPP_p0r0_vpp6p00_bl0 vpp_p0r0_vpp6p00_bl0 0 DC 6.000000e+00
VBL_p0r0_vpp6p00_bl0 bl_p0r0_vpp6p00_bl0 0 DC 0.000000e+00
VPEN_p0r0_vpp6p00_bl0 pen_p0r0_vpp6p00_bl0 0 DC 0
VREN_p0r0_vpp6p00_bl0 ren_p0r0_vpp6p00_bl0 0 DC 0
VAMP_p0r0_vpp6p00_bl0 blp_p0r0_vpp6p00_bl0 bl_p0r0_vpp6p00_bl0 DC 0
VAMR_p0r0_vpp6p00_bl0 blr_p0r0_vpp6p00_bl0 bl_p0r0_vpp6p00_bl0 DC 0
XPG_p0r0_vpp6p00_bl0 pen_p0r0_vpp6p00_bl0 ren_p0r0_vpp6p00_bl0 vdd 0 blp_p0r0_vpp6p00_bl0 vpp_p0r0_vpp6p00_bl0 program_leg
XRD_p0r0_vpp6p00_bl0 pen_p0r0_vpp6p00_bl0 ren_p0r0_vpp6p00_bl0 vclamp iref_p0r0_vpp6p00_bl0 vdd 0 blr_p0r0_vpp6p00_bl0 sense_p0r0_vpp6p00_bl0 rdata_p0r0_vpp6p00_bl0 read_leg
IREF_p0r0_vpp6p00_bl0 0 iref_p0r0_vpp6p00_bl0 DC 1.000000e-06
* ---- p0r0_vpp6p00_blvpp ----
VPP_p0r0_vpp6p00_blvpp vpp_p0r0_vpp6p00_blvpp 0 DC 6.000000e+00
VBL_p0r0_vpp6p00_blvpp bl_p0r0_vpp6p00_blvpp 0 DC 6.000000e+00
VPEN_p0r0_vpp6p00_blvpp pen_p0r0_vpp6p00_blvpp 0 DC 0
VREN_p0r0_vpp6p00_blvpp ren_p0r0_vpp6p00_blvpp 0 DC 0
VAMP_p0r0_vpp6p00_blvpp blp_p0r0_vpp6p00_blvpp bl_p0r0_vpp6p00_blvpp DC 0
VAMR_p0r0_vpp6p00_blvpp blr_p0r0_vpp6p00_blvpp bl_p0r0_vpp6p00_blvpp DC 0
XPG_p0r0_vpp6p00_blvpp pen_p0r0_vpp6p00_blvpp ren_p0r0_vpp6p00_blvpp vdd 0 blp_p0r0_vpp6p00_blvpp vpp_p0r0_vpp6p00_blvpp program_leg
XRD_p0r0_vpp6p00_blvpp pen_p0r0_vpp6p00_blvpp ren_p0r0_vpp6p00_blvpp vclamp iref_p0r0_vpp6p00_blvpp vdd 0 blr_p0r0_vpp6p00_blvpp sense_p0r0_vpp6p00_blvpp rdata_p0r0_vpp6p00_blvpp read_leg
IREF_p0r0_vpp6p00_blvpp 0 iref_p0r0_vpp6p00_blvpp DC 1.000000e-06
* ---- p1r0_vpp3p63_bl0 ----
VPP_p1r0_vpp3p63_bl0 vpp_p1r0_vpp3p63_bl0 0 DC 3.630000e+00
VBL_p1r0_vpp3p63_bl0 bl_p1r0_vpp3p63_bl0 0 DC 0.000000e+00
EPEN_p1r0_vpp3p63_bl0 pen_p1r0_vpp3p63_bl0 0 hi 0 1
VREN_p1r0_vpp3p63_bl0 ren_p1r0_vpp3p63_bl0 0 DC 0
VAMP_p1r0_vpp3p63_bl0 blp_p1r0_vpp3p63_bl0 bl_p1r0_vpp3p63_bl0 DC 0
VAMR_p1r0_vpp3p63_bl0 blr_p1r0_vpp3p63_bl0 bl_p1r0_vpp3p63_bl0 DC 0
XPG_p1r0_vpp3p63_bl0 pen_p1r0_vpp3p63_bl0 ren_p1r0_vpp3p63_bl0 vdd 0 blp_p1r0_vpp3p63_bl0 vpp_p1r0_vpp3p63_bl0 program_leg
XRD_p1r0_vpp3p63_bl0 pen_p1r0_vpp3p63_bl0 ren_p1r0_vpp3p63_bl0 vclamp iref_p1r0_vpp3p63_bl0 vdd 0 blr_p1r0_vpp3p63_bl0 sense_p1r0_vpp3p63_bl0 rdata_p1r0_vpp3p63_bl0 read_leg
IREF_p1r0_vpp3p63_bl0 0 iref_p1r0_vpp3p63_bl0 DC 1.000000e-06
* ---- p1r0_vpp3p63_blvpp ----
VPP_p1r0_vpp3p63_blvpp vpp_p1r0_vpp3p63_blvpp 0 DC 3.630000e+00
VBL_p1r0_vpp3p63_blvpp bl_p1r0_vpp3p63_blvpp 0 DC 3.630000e+00
EPEN_p1r0_vpp3p63_blvpp pen_p1r0_vpp3p63_blvpp 0 hi 0 1
VREN_p1r0_vpp3p63_blvpp ren_p1r0_vpp3p63_blvpp 0 DC 0
VAMP_p1r0_vpp3p63_blvpp blp_p1r0_vpp3p63_blvpp bl_p1r0_vpp3p63_blvpp DC 0
VAMR_p1r0_vpp3p63_blvpp blr_p1r0_vpp3p63_blvpp bl_p1r0_vpp3p63_blvpp DC 0
XPG_p1r0_vpp3p63_blvpp pen_p1r0_vpp3p63_blvpp ren_p1r0_vpp3p63_blvpp vdd 0 blp_p1r0_vpp3p63_blvpp vpp_p1r0_vpp3p63_blvpp program_leg
XRD_p1r0_vpp3p63_blvpp pen_p1r0_vpp3p63_blvpp ren_p1r0_vpp3p63_blvpp vclamp iref_p1r0_vpp3p63_blvpp vdd 0 blr_p1r0_vpp3p63_blvpp sense_p1r0_vpp3p63_blvpp rdata_p1r0_vpp3p63_blvpp read_leg
IREF_p1r0_vpp3p63_blvpp 0 iref_p1r0_vpp3p63_blvpp DC 1.000000e-06
* ---- p1r0_vpp6p00_bl0 ----
VPP_p1r0_vpp6p00_bl0 vpp_p1r0_vpp6p00_bl0 0 DC 6.000000e+00
VBL_p1r0_vpp6p00_bl0 bl_p1r0_vpp6p00_bl0 0 DC 0.000000e+00
EPEN_p1r0_vpp6p00_bl0 pen_p1r0_vpp6p00_bl0 0 hi 0 1
VREN_p1r0_vpp6p00_bl0 ren_p1r0_vpp6p00_bl0 0 DC 0
VAMP_p1r0_vpp6p00_bl0 blp_p1r0_vpp6p00_bl0 bl_p1r0_vpp6p00_bl0 DC 0
VAMR_p1r0_vpp6p00_bl0 blr_p1r0_vpp6p00_bl0 bl_p1r0_vpp6p00_bl0 DC 0
XPG_p1r0_vpp6p00_bl0 pen_p1r0_vpp6p00_bl0 ren_p1r0_vpp6p00_bl0 vdd 0 blp_p1r0_vpp6p00_bl0 vpp_p1r0_vpp6p00_bl0 program_leg
XRD_p1r0_vpp6p00_bl0 pen_p1r0_vpp6p00_bl0 ren_p1r0_vpp6p00_bl0 vclamp iref_p1r0_vpp6p00_bl0 vdd 0 blr_p1r0_vpp6p00_bl0 sense_p1r0_vpp6p00_bl0 rdata_p1r0_vpp6p00_bl0 read_leg
IREF_p1r0_vpp6p00_bl0 0 iref_p1r0_vpp6p00_bl0 DC 1.000000e-06
* ---- p1r0_vpp6p00_blvpp ----
VPP_p1r0_vpp6p00_blvpp vpp_p1r0_vpp6p00_blvpp 0 DC 6.000000e+00
VBL_p1r0_vpp6p00_blvpp bl_p1r0_vpp6p00_blvpp 0 DC 6.000000e+00
EPEN_p1r0_vpp6p00_blvpp pen_p1r0_vpp6p00_blvpp 0 hi 0 1
VREN_p1r0_vpp6p00_blvpp ren_p1r0_vpp6p00_blvpp 0 DC 0
VAMP_p1r0_vpp6p00_blvpp blp_p1r0_vpp6p00_blvpp bl_p1r0_vpp6p00_blvpp DC 0
VAMR_p1r0_vpp6p00_blvpp blr_p1r0_vpp6p00_blvpp bl_p1r0_vpp6p00_blvpp DC 0
XPG_p1r0_vpp6p00_blvpp pen_p1r0_vpp6p00_blvpp ren_p1r0_vpp6p00_blvpp vdd 0 blp_p1r0_vpp6p00_blvpp vpp_p1r0_vpp6p00_blvpp program_leg
XRD_p1r0_vpp6p00_blvpp pen_p1r0_vpp6p00_blvpp ren_p1r0_vpp6p00_blvpp vclamp iref_p1r0_vpp6p00_blvpp vdd 0 blr_p1r0_vpp6p00_blvpp sense_p1r0_vpp6p00_blvpp rdata_p1r0_vpp6p00_blvpp read_leg
IREF_p1r0_vpp6p00_blvpp 0 iref_p1r0_vpp6p00_blvpp DC 1.000000e-06
* ---- p0r1_vpp3p63_bl0 ----
VPP_p0r1_vpp3p63_bl0 vpp_p0r1_vpp3p63_bl0 0 DC 3.630000e+00
VBL_p0r1_vpp3p63_bl0 bl_p0r1_vpp3p63_bl0 0 DC 0.000000e+00
VPEN_p0r1_vpp3p63_bl0 pen_p0r1_vpp3p63_bl0 0 DC 0
EREN_p0r1_vpp3p63_bl0 ren_p0r1_vpp3p63_bl0 0 hi 0 1
VAMP_p0r1_vpp3p63_bl0 blp_p0r1_vpp3p63_bl0 bl_p0r1_vpp3p63_bl0 DC 0
VAMR_p0r1_vpp3p63_bl0 blr_p0r1_vpp3p63_bl0 bl_p0r1_vpp3p63_bl0 DC 0
XPG_p0r1_vpp3p63_bl0 pen_p0r1_vpp3p63_bl0 ren_p0r1_vpp3p63_bl0 vdd 0 blp_p0r1_vpp3p63_bl0 vpp_p0r1_vpp3p63_bl0 program_leg
XRD_p0r1_vpp3p63_bl0 pen_p0r1_vpp3p63_bl0 ren_p0r1_vpp3p63_bl0 vclamp iref_p0r1_vpp3p63_bl0 vdd 0 blr_p0r1_vpp3p63_bl0 sense_p0r1_vpp3p63_bl0 rdata_p0r1_vpp3p63_bl0 read_leg
IREF_p0r1_vpp3p63_bl0 0 iref_p0r1_vpp3p63_bl0 DC 1.000000e-06
* ---- p0r1_vpp6p00_bl0 ----
VPP_p0r1_vpp6p00_bl0 vpp_p0r1_vpp6p00_bl0 0 DC 6.000000e+00
VBL_p0r1_vpp6p00_bl0 bl_p0r1_vpp6p00_bl0 0 DC 0.000000e+00
VPEN_p0r1_vpp6p00_bl0 pen_p0r1_vpp6p00_bl0 0 DC 0
EREN_p0r1_vpp6p00_bl0 ren_p0r1_vpp6p00_bl0 0 hi 0 1
VAMP_p0r1_vpp6p00_bl0 blp_p0r1_vpp6p00_bl0 bl_p0r1_vpp6p00_bl0 DC 0
VAMR_p0r1_vpp6p00_bl0 blr_p0r1_vpp6p00_bl0 bl_p0r1_vpp6p00_bl0 DC 0
XPG_p0r1_vpp6p00_bl0 pen_p0r1_vpp6p00_bl0 ren_p0r1_vpp6p00_bl0 vdd 0 blp_p0r1_vpp6p00_bl0 vpp_p0r1_vpp6p00_bl0 program_leg
XRD_p0r1_vpp6p00_bl0 pen_p0r1_vpp6p00_bl0 ren_p0r1_vpp6p00_bl0 vclamp iref_p0r1_vpp6p00_bl0 vdd 0 blr_p0r1_vpp6p00_bl0 sense_p0r1_vpp6p00_bl0 rdata_p0r1_vpp6p00_bl0 read_leg
IREF_p0r1_vpp6p00_bl0 0 iref_p0r1_vpp6p00_bl0 DC 1.000000e-06
* ---- p1r1_vpp3p63_bl0 ----
VPP_p1r1_vpp3p63_bl0 vpp_p1r1_vpp3p63_bl0 0 DC 3.630000e+00
VBL_p1r1_vpp3p63_bl0 bl_p1r1_vpp3p63_bl0 0 DC 0.000000e+00
EPEN_p1r1_vpp3p63_bl0 pen_p1r1_vpp3p63_bl0 0 hi 0 1
EREN_p1r1_vpp3p63_bl0 ren_p1r1_vpp3p63_bl0 0 hi 0 1
VAMP_p1r1_vpp3p63_bl0 blp_p1r1_vpp3p63_bl0 bl_p1r1_vpp3p63_bl0 DC 0
VAMR_p1r1_vpp3p63_bl0 blr_p1r1_vpp3p63_bl0 bl_p1r1_vpp3p63_bl0 DC 0
XPG_p1r1_vpp3p63_bl0 pen_p1r1_vpp3p63_bl0 ren_p1r1_vpp3p63_bl0 vdd 0 blp_p1r1_vpp3p63_bl0 vpp_p1r1_vpp3p63_bl0 program_leg
XRD_p1r1_vpp3p63_bl0 pen_p1r1_vpp3p63_bl0 ren_p1r1_vpp3p63_bl0 vclamp iref_p1r1_vpp3p63_bl0 vdd 0 blr_p1r1_vpp3p63_bl0 sense_p1r1_vpp3p63_bl0 rdata_p1r1_vpp3p63_bl0 read_leg
IREF_p1r1_vpp3p63_bl0 0 iref_p1r1_vpp3p63_bl0 DC 1.000000e-06
* ---- p1r1_vpp3p63_blvpp ----
VPP_p1r1_vpp3p63_blvpp vpp_p1r1_vpp3p63_blvpp 0 DC 3.630000e+00
VBL_p1r1_vpp3p63_blvpp bl_p1r1_vpp3p63_blvpp 0 DC 3.630000e+00
EPEN_p1r1_vpp3p63_blvpp pen_p1r1_vpp3p63_blvpp 0 hi 0 1
EREN_p1r1_vpp3p63_blvpp ren_p1r1_vpp3p63_blvpp 0 hi 0 1
VAMP_p1r1_vpp3p63_blvpp blp_p1r1_vpp3p63_blvpp bl_p1r1_vpp3p63_blvpp DC 0
VAMR_p1r1_vpp3p63_blvpp blr_p1r1_vpp3p63_blvpp bl_p1r1_vpp3p63_blvpp DC 0
XPG_p1r1_vpp3p63_blvpp pen_p1r1_vpp3p63_blvpp ren_p1r1_vpp3p63_blvpp vdd 0 blp_p1r1_vpp3p63_blvpp vpp_p1r1_vpp3p63_blvpp program_leg
XRD_p1r1_vpp3p63_blvpp pen_p1r1_vpp3p63_blvpp ren_p1r1_vpp3p63_blvpp vclamp iref_p1r1_vpp3p63_blvpp vdd 0 blr_p1r1_vpp3p63_blvpp sense_p1r1_vpp3p63_blvpp rdata_p1r1_vpp3p63_blvpp read_leg
IREF_p1r1_vpp3p63_blvpp 0 iref_p1r1_vpp3p63_blvpp DC 1.000000e-06
* ---- p1r1_vpp6p00_bl0 ----
VPP_p1r1_vpp6p00_bl0 vpp_p1r1_vpp6p00_bl0 0 DC 6.000000e+00
VBL_p1r1_vpp6p00_bl0 bl_p1r1_vpp6p00_bl0 0 DC 0.000000e+00
EPEN_p1r1_vpp6p00_bl0 pen_p1r1_vpp6p00_bl0 0 hi 0 1
EREN_p1r1_vpp6p00_bl0 ren_p1r1_vpp6p00_bl0 0 hi 0 1
VAMP_p1r1_vpp6p00_bl0 blp_p1r1_vpp6p00_bl0 bl_p1r1_vpp6p00_bl0 DC 0
VAMR_p1r1_vpp6p00_bl0 blr_p1r1_vpp6p00_bl0 bl_p1r1_vpp6p00_bl0 DC 0
XPG_p1r1_vpp6p00_bl0 pen_p1r1_vpp6p00_bl0 ren_p1r1_vpp6p00_bl0 vdd 0 blp_p1r1_vpp6p00_bl0 vpp_p1r1_vpp6p00_bl0 program_leg
XRD_p1r1_vpp6p00_bl0 pen_p1r1_vpp6p00_bl0 ren_p1r1_vpp6p00_bl0 vclamp iref_p1r1_vpp6p00_bl0 vdd 0 blr_p1r1_vpp6p00_bl0 sense_p1r1_vpp6p00_bl0 rdata_p1r1_vpp6p00_bl0 read_leg
IREF_p1r1_vpp6p00_bl0 0 iref_p1r1_vpp6p00_bl0 DC 1.000000e-06
* ---- p1r1_vpp6p00_blvpp ----
VPP_p1r1_vpp6p00_blvpp vpp_p1r1_vpp6p00_blvpp 0 DC 6.000000e+00
VBL_p1r1_vpp6p00_blvpp bl_p1r1_vpp6p00_blvpp 0 DC 6.000000e+00
EPEN_p1r1_vpp6p00_blvpp pen_p1r1_vpp6p00_blvpp 0 hi 0 1
EREN_p1r1_vpp6p00_blvpp ren_p1r1_vpp6p00_blvpp 0 hi 0 1
VAMP_p1r1_vpp6p00_blvpp blp_p1r1_vpp6p00_blvpp bl_p1r1_vpp6p00_blvpp DC 0
VAMR_p1r1_vpp6p00_blvpp blr_p1r1_vpp6p00_blvpp bl_p1r1_vpp6p00_blvpp DC 0
XPG_p1r1_vpp6p00_blvpp pen_p1r1_vpp6p00_blvpp ren_p1r1_vpp6p00_blvpp vdd 0 blp_p1r1_vpp6p00_blvpp vpp_p1r1_vpp6p00_blvpp program_leg
XRD_p1r1_vpp6p00_blvpp pen_p1r1_vpp6p00_blvpp ren_p1r1_vpp6p00_blvpp vclamp iref_p1r1_vpp6p00_blvpp vdd 0 blr_p1r1_vpp6p00_blvpp sense_p1r1_vpp6p00_blvpp rdata_p1r1_vpp6p00_blvpp read_leg
IREF_p1r1_vpp6p00_blvpp 0 iref_p1r1_vpp6p00_blvpp DC 1.000000e-06
