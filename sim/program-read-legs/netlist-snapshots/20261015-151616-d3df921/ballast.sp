* gf180-antifuse sim/program-read-legs -- ballast / compliance bench (program leg, BL held at V_compliance)
* GENERATED by sim/program-read-legs/benches.py -- do not edit.
* Netlist body for klt sim: no .control/.end (klt appends them).
.include ../../../design/netlists/leg_interlock.spice
.include ../../../design/netlists/program_leg.spice
.include ../../../design/netlists/read_leg.spice
VDD vdd 0 DC 3.300000e+00
VCLAMP vclamp 0 DC 1.800000e+00
* logic highs track VDD (E sources) so the corner's VDD moves them too
EHI hi 0 vdd 0 1
EPEN pen 0 hi 0 1
VREN ren 0 DC 0
* ---- vpp4p0_comp ----
VPP_vpp4p0_comp vpp_vpp4p0_comp 0 DC 4.000000e+00
VBL_vpp4p0_comp bl_vpp4p0_comp 0 DC 1.000000e+00
VAM_vpp4p0_comp blp_vpp4p0_comp bl_vpp4p0_comp DC 0
XPG_vpp4p0_comp pen ren vdd 0 blp_vpp4p0_comp vpp_vpp4p0_comp program_leg
* ---- vpp4p0_short ----
VPP_vpp4p0_short vpp_vpp4p0_short 0 DC 4.000000e+00
VBL_vpp4p0_short bl_vpp4p0_short 0 DC 0.000000e+00
VAM_vpp4p0_short blp_vpp4p0_short bl_vpp4p0_short DC 0
XPG_vpp4p0_short pen ren vdd 0 blp_vpp4p0_short vpp_vpp4p0_short program_leg
* ---- vpp5p0_comp ----
VPP_vpp5p0_comp vpp_vpp5p0_comp 0 DC 5.000000e+00
VBL_vpp5p0_comp bl_vpp5p0_comp 0 DC 1.000000e+00
VAM_vpp5p0_comp blp_vpp5p0_comp bl_vpp5p0_comp DC 0
XPG_vpp5p0_comp pen ren vdd 0 blp_vpp5p0_comp vpp_vpp5p0_comp program_leg
* ---- vpp5p0_short ----
VPP_vpp5p0_short vpp_vpp5p0_short 0 DC 5.000000e+00
VBL_vpp5p0_short bl_vpp5p0_short 0 DC 0.000000e+00
VAM_vpp5p0_short blp_vpp5p0_short bl_vpp5p0_short DC 0
XPG_vpp5p0_short pen ren vdd 0 blp_vpp5p0_short vpp_vpp5p0_short program_leg
* ---- vpp6p0_comp ----
VPP_vpp6p0_comp vpp_vpp6p0_comp 0 DC 6.000000e+00
VBL_vpp6p0_comp bl_vpp6p0_comp 0 DC 1.000000e+00
VAM_vpp6p0_comp blp_vpp6p0_comp bl_vpp6p0_comp DC 0
XPG_vpp6p0_comp pen ren vdd 0 blp_vpp6p0_comp vpp_vpp6p0_comp program_leg
* ---- vpp6p0_short ----
VPP_vpp6p0_short vpp_vpp6p0_short 0 DC 6.000000e+00
VBL_vpp6p0_short bl_vpp6p0_short 0 DC 0.000000e+00
VAM_vpp6p0_short blp_vpp6p0_short bl_vpp6p0_short DC 0
XPG_vpp6p0_short pen ren vdd 0 blp_vpp6p0_short vpp_vpp6p0_short program_leg
