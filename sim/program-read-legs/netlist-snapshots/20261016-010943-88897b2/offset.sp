* gf180-antifuse sim/program-read-legs -- mirror-offset bench (read leg, BL sunk at I_ref, SENSE forced to VDD/2)
* GENERATED by sim/program-read-legs/benches.py -- do not edit.
* Netlist body for klt sim: no .control/.end (klt appends them).
.include ../../../design/netlists/leg_interlock.spice
.include ../../../design/netlists/program_leg.spice
.include ../../../design/netlists/read_leg.spice
VDD vdd 0 DC 3.300000e+00
VCLAMP vclamp 0 DC 1.800000e+00
* logic highs track VDD (E sources) so the corner's VDD moves them too
EHI hi 0 vdd 0 1
EHALF half 0 vdd 0 0.5
VPEN prog_en 0 DC 0
EREN read_en 0 hi 0 1
VPPIDLE vppi 0 DC 6.000000e+00
* ---- instance o0 ----
ISNK_o0 bl_o0 0 DC 1.000000e-06
VSNS_o0 sense_o0 half DC 0
XRD_o0 prog_en read_en vclamp iref_o0 vdd 0 bl_o0 sense_o0 rdata_o0 read_leg
IREF_o0 0 iref_o0 DC 1.000000e-06
* ---- instance o1 ----
ISNK_o1 bl_o1 0 DC 1.000000e-06
VSNS_o1 sense_o1 half DC 0
XRD_o1 prog_en read_en vclamp iref_o1 vdd 0 bl_o1 sense_o1 rdata_o1 read_leg
IREF_o1 0 iref_o1 DC 1.000000e-06
* ---- instance o2 ----
ISNK_o2 bl_o2 0 DC 1.000000e-06
VSNS_o2 sense_o2 half DC 0
XRD_o2 prog_en read_en vclamp iref_o2 vdd 0 bl_o2 sense_o2 rdata_o2 read_leg
IREF_o2 0 iref_o2 DC 1.000000e-06
* ---- instance o3 ----
ISNK_o3 bl_o3 0 DC 1.000000e-06
VSNS_o3 sense_o3 half DC 0
XRD_o3 prog_en read_en vclamp iref_o3 vdd 0 bl_o3 sense_o3 rdata_o3 read_leg
IREF_o3 0 iref_o3 DC 1.000000e-06
