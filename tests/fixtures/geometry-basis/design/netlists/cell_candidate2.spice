* Fixture cell netlist for tests/test_check_geometry_basis.py.
* Only the .subckt parameter defaults are read by design/check-geometry-basis.py.
.subckt cell_candidate2 BL WL PL VB  wcap=2e-6 lcap=1e-6 wacc=0.50u lacc=0.60u
XM1 BL WL CN VB nfet_10v0_asym L=lacc W=wacc nf=1 m=1
XC1 CN PL cap_nmos_06v0 c_width=wcap c_length=lcap m=1
.ends
