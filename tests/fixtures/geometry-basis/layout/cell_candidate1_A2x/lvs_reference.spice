* Fixture LVS reference: drawn capacitor length already equals the ratified
* Minimum (0.28 um, cap_nmos_03v3) while the simulated basis still carries the
* placeholder lcap default - the "simulated side is the stale one" divergence
* shape (owner: the netlist regeneration, not the redraw).
.subckt cell_candidate1_A2x BL WL PL VB
XM1 BL WL CN VB nfet_06v0 L=0.70u W=0.60u nf=1 m=1
XC1 CN PL cap_nmos_03v3 c_width=1e-6 c_length=0.28u m=1
.ends
