* Fixture LVS reference: matches the simulated basis exactly at (access min, capacitor min).
.subckt cell_candidate1 BL WL PL VB
XM1 BL WL CN VB nfet_06v0 L=0.70u W=0.30u nf=1 m=1
XC1 CN PL cap_nmos_03v3 c_width=1e-6 c_length=1e-6 m=1
.ends
