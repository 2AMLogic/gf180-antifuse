* Fixture LVS reference: matches the simulated basis exactly at (access 2x, capacitor 2x).
.subckt cell_candidate1_A2x_G2x BL WL PL VB
XM1 BL WL CN VB nfet_06v0 L=0.70u W=0.60u nf=1 m=1
XC1 CN PL cap_nmos_03v3 c_width=2e-6 c_length=1e-6 m=1
.ends
